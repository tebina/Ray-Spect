//---------------------------------------------------
// SPECTRE DIRECT
// MOS transistor library file
//---------------------------------------------------
library cmos
section cmostm
//
// ----------------------------------------------------------------------
// Owner: austriamicrosystems
// HIT-Kit: Digital
// ************************ SIMULATION PARAMETERS ************************
//  ----------------------------------------------------------------------
//  format    : Spectre (Spectre Direct)
//  model     : MOS BSIM3v3
//  process   : C35
//  revision  : 4.0;
//  extracted : B10866 ; 2002-12; ese(5487)
//  doc#      : ENG-182 REV_6
//  ----------------------------------------------------------------------
//                          TYPICAL MEAN CONDITION
//
//  ----------------------------------------------------------------------
//
inline subckt modn ( d g s b )
parameters w=1.0e-6 l=1.0e-6 nrd=0.0 nrs=0.0 ad=0.0 as=0.0 pd=0.0 ps=0.0 ng=1 vthadd=0.0 iladd=0.0
+ ws= w
+ ls= l
+ shk=1
//
if (modn==1)
modn ( d g s b ) mosinsub w=ws l=ls nrd=nrd nrs=nrs ad=ad as=as pd=pd ps=ps m=ng
else
modn ( d s ) resistor r=1e30
notvalid paramtest errorif=(modn==0) \
message="
***************************************************
*
* nmos is not valid in selected process option.
*
***************************************************"
model mosinsub bsim3v3 version=3.2400e+00  type=n  capmod=2.0000e+00 \
 mobmod=1.0000e+00  nqsmod=0.0000e+00  noimod=3 \
   vbox=1.000e+03      k1=5.0296e-01 \
     k2=3.3985e-02      k3=-1.136e+00     k3b=-4.399e-01 \
    nch=2.6110e+17 vth0=4.9790e-01+vthadd\
   voff=-8.925e-02    dvt0=5.0000e+01    dvt1=1.0390e+00 \
   dvt2=-8.375e-03    keta=2.0320e-02 \
 pscbe1=1.0000e+30  pscbe2=1.0000e-06 \
 alpha0=2.6000e-06  alpha1=5.0000e+00   beta0=2.1000e+01 \
  dvt0w=1.0890e-01   dvt1w=6.6710e+04   dvt2w=-1.352e-02 \
     ua=4.7050e-12      ub=2.1370e-18      uc=1.0000e-20 \
u0=4.7580e+02 \
   dsub=5.0000e-01    eta0=1.4150e-02    etab=-1.221e-01 \
nfactor=4.1360e-01 \
     em=4.1000e+07    pclm=6.9480e-01 \
  drout=5.0000e-01 \
     a0=2.5410e+00      a1=0.0000e+00      a2=1.0000e+00 \
   pvag=0.0000e+00    vsat=1.3380e+05     ags=2.4080e-01      b0=4.3010e-09      b1=0.0000e+00 \
  delta=1.4420e-02 pdiblcb=3.2220e-01 \
pdiblc1=3.5710e-01 pdiblc2=2.0650e-03 \
     w0=2.6730e-07 \
    dlc=3.0000e-08 \
    dwc=9.4030e-08     dwb=0.0000e+00     dwg=0.0000e+00 \
     ll=0.000e+00      lw=0.000e+00     lwl=0.000e+00 \
    lln=1.000e+00     lwn=1.000e+00      wl=0.0000e+00 \
     ww=-1.297e-14     wwl=-9.411e-21     wln=1.0000e+00 \
     wr=1.0000e+00     wwn=1.0000e+00 \
     at=3.3000e+04     ute=-1.800e+00 \
    kt1=-3.302e-01     kt2=2.2000e-02    kt1l=0.0000e+00 \
    ua1=0.0000e+00     ub1=0.0000e+00     uc1=0.0000e+00 \
    prt=0.0000e+00 \
   cgso=1.2000e-10    cgdo=1.2000e-10    cgbo=1.1000e-10 \
   cgdl=1.3100e-10    cgsl=1.3100e-10  ckappa=6.0000e-01 \
     cf=0.0000e+00     elm=5.0000e+00 \
  xpart=1.0000e+00     clc=1.0000e-15     cle=6.0000e-01 \
   noff=1.0000e+00  voffcv=0.0000e+00 \
   rdsw=3.4490e+02 \
   cdsc=0.0000e+00   cdscb=1.5000e-03   cdscd=1.0000e-03 \
   prwb=-2.416e-01    prwg=0.0000e+00     cit=4.4410e-04 \
tox=7.5750e-09 \
  ngate=0.0000e+00 \
    nlx=1.8880e-07 \
     xl=0.0000e+00      xw=0.0000e+00 \
     af=1.5070e+00      kf=2.1700e-26      ef=1.0000e+00 \
   noia=1.1210e+19    noib=5.3360e+04    noic=-5.892e-13 \
     rd=0.0000e+00      rs=0.0000e+00     rsh=7.0000e+01 \
   minr=1.000e-03 \
    rdc=0.0000e+00     rsc=0.0000e+00 lint=-5.005e-08 \
wint=9.4030e-08   ldif=0.000e+00    hdif=8.0000e-07 \
     xj=3.0000e-07      js=5.1000e-07 \
      n=1.0000e+00 \
  dskip=no          tlev=0           tlevc=0         \
    jsw=6.0000e-13 \
     cj=8.4000e-04    cjsw=2.5000e-10 \
     fc=0.0000e+00    fcsw=0.000e+00 \
     mj=3.4000e-01    mjsw=2.3000e-01 \
     pb=6.9000e-01    pbsw=6.9000e-01     xti=2.0260e+00
ends modn

// ----------------------------------------------------------------------
// ----------------------------------------------------------------------
// Owner: austriamicrosystems
// HIT-Kit: Digital
// ************************ SIMULATION PARAMETERS ************************
//  ----------------------------------------------------------------------
//  format    : Spectre (Spectre Direct)
//  model     : MOS BSIM3v3
//  process   : C35
//  revision  : 4.1;
//  extracted : B11004 ; 2002-12; ese(5487)
//  doc#      : ENG-182 REV_6
//  ----------------------------------------------------------------------
//                          TYPICAL MEAN CONDITION
//
//  ----------------------------------------------------------------------
//
inline subckt modnm ( d g s b )
parameters w=1.0e-6 l=1.0e-6 nrd=0.0 nrs=0.0 ad=0.0 as=0.0 pd=0.0 ps=0.0 ng=1 vthadd=0.0
+ ws= w
+ ls= l
+ shk=1
//
if (modnm==1)
modnm ( d g s b ) mosinsub w=ws l=ls nrd=nrd nrs=nrs ad=ad as=as pd=pd ps=ps m=ng
else
modnm ( d s ) resistor r=1e30
notvalid paramtest errorif=(modnm==0) \
message="
***************************************************
*
* nmosm is not valid in selected process option.
*
***************************************************"
model mosinsub bsim3v3 version=3.2400e+00  type=n  capmod=2.0000e+00 \
 mobmod=1.0000e+00  nqsmod=0.0000e+00  noimod=3 \
   vbox=1.000e+03      k1=7.4922e-01 \
     k2=1.1026e-01      k3=-3.776e+00     k3b=-7.691e-02 \
    nch=2.2650e+17 vth0=7.5250e-01 + vthadd\
   voff=-8.295e-02    dvt0=3.0000e+01    dvt1=1.5280e+00 \
   dvt2=2.5290e-02    keta=3.5850e-02 \
 pscbe1=1.0000e+30  pscbe2=1.0000e-06 \
 alpha0=7.7410e-09  alpha1=3.9830e-01   beta0=2.0700e+01 \
  dvt0w=-5.000e+00   dvt1w=2.5780e+06   dvt2w=5.1050e-02 \
     ua=4.7080e-10      ub=1.4700e-18      uc=-4.342e-11 \
u0=5.6430e+02 \
   dsub=5.0000e-01    eta0=3.7950e-02    etab=-7.653e-04 \
nfactor=8.5730e-01 \
     em=4.1000e+07    pclm=2.1250e-01 \
  drout=5.0000e-01 \
     a0=2.0640e+00      a1=0.0000e+00      a2=1.0000e+00 \
   pvag=0.0000e+00    vsat=1.0780e+05     ags=1.0790e-01      b0=-1.493e-07      b1=0.0000e+00 \
  delta=1.0000e-02 pdiblcb=5.1860e-01 \
pdiblc1=1.0000e-04 pdiblc2=5.4580e-04 \
     w0=1.6170e-07 \
    dlc=1.0000e-07 \
    dwc=1.6230e-07     dwb=0.0000e+00     dwg=0.0000e+00 \
     ll=0.000e+00      lw=0.000e+00     lwl=0.000e+00 \
    lln=1.000e+00     lwn=1.000e+00      wl=0.0000e+00 \
     ww=-5.117e-14     wwl=-5.704e-21     wln=1.0000e+00 \
     wr=1.0000e+00     wwn=1.0000e+00 \
     at=3.3000e+04     ute=-1.760e+00 \
    kt1=-4.502e-01     kt2=2.2000e-02    kt1l=0.0000e+00 \
    ua1=0.0000e+00     ub1=0.0000e+00     uc1=0.0000e+00 \
    prt=0.0000e+00 \
   cgso=1.0800e-10    cgdo=1.0800e-10    cgbo=1.1000e-10 \
   cgdl=2.2700e-10    cgsl=2.2700e-10  ckappa=6.0000e-01 \
     cf=0.0000e+00     elm=5.0000e+00 \
  xpart=1.0000e+00     clc=1.0000e-15     cle=6.0000e-01 \
   noff=1.0000e+00  voffcv=0.0000e+00 \
   rdsw=1.3900e+03 \
   cdsc=0.0000e+00   cdscb=-1.500e-03   cdscd=0.0000e+00 \
   prwb=-6.740e-02    prwg=0.0000e+00     cit=0.0000e+00 \
tox=1.5160e-08 \
  ngate=0.0000e+00 \
    nlx=2.2830e-07 \
     xl=0.0000e+00      xw=0.0000e+00 \
     af=1.6290e+00      kf=9.1800e-26      ef=1.0000e+00 \
   noia=2.2450e+19    noib=1.1680e+05    noic=-1.680e-12 \
     rd=0.0000e+00      rs=0.0000e+00     rsh=7.9000e+01 \
   minr=1.000e-03 \
    rdc=0.0000e+00     rsc=0.0000e+00 lint=1.2250e-07 \
wint=1.6230e-07   ldif=0.000e+00    hdif=6.0000e-07 \
     xj=3.0000e-07      js=5.1000e-07 \
      n=1.0000e+00 \
  dskip=no          tlev=0           tlevc=0         \
    jsw=6.0000e-13 \
     cj=8.3000e-04    cjsw=2.5000e-10 \
     fc=0.0000e+00    fcsw=0.000e+00 \
     mj=3.4000e-01    mjsw=2.3000e-01 \
     pb=6.9000e-01    pbsw=6.9000e-01     xti=2.0260e+00
ends modnm

// ----------------------------------------------------------------------

// ----------------------------------------------------------------------
// Owner: austriamicrosystems
// HIT-Kit: Digital
// ************************ SIMULATION PARAMETERS ************************
//  ----------------------------------------------------------------------
//  format    : Spectre (Spectre Direct)
//  model     : MOS BSIM3v3
//  process   : C35
//  revision  : 5.0;
//  extracted : B27167L1W5C45; 15-04-2007; bse (5866)
//  doc#      : Eng-182 REV_6
//  ----------------------------------------------------------------------
//                          TYPICAL MEAN CONDITION
//
//  ----------------------------------------------------------------------
//
inline subckt modnl ( d g s b )
parameters w=1.0e-6 l=1.0e-6 nrd=0.0 nrs=0.0 ad=0.0 as=0.0 pd=0.0 ps=0.0 ng=1
+ ws= w
+ ls= l
+ shk=1
//
if (modnl==1)
modnl ( d g s b ) mosinsub w=ws l=ls nrd=8.0000e-07/ws nrs=8.0000e-07/ws ad=ad as=as pd=pd ps=ps m=ng
else
modnl ( d s ) resistor r=1e30
notvalid paramtest errorif=(modnl==0) \
message="
***************************************************
*
* nmosl is not valid in selected process option.
*
***************************************************"
model mosinsub bsim3v3 version=3.2400e+00  type=n  capmod=2.0000e+00 \
 mobmod=1.0000e+00  nqsmod=0.0000e+00  noimod=3.0000e+00 \
   vbox=1.000e+03      k1=5.4000e-01 \
     k2=0.0000e+00      k3=7.6040e+00     k3b=0.0000e+00 \
    nch=2.1870e+17 vth0=4.2200e-01 \
   voff=-8.000e-02    dvt0=1.2570e+01    dvt1=8.1290e-01 \
   dvt2=2.2200e-15    keta=-2.800e-03 \
 pscbe1=1.0000e+30  pscbe2=1.0000e-06 \
 alpha0=1.9000e-06  alpha1=1.0000e+00   beta0=2.0000e+01 \
  dvt0w=0.0000e+00   dvt1w=1.6970e+06   dvt2w=2.5060e-01 \
     ua=1.0000e-12      ub=2.1880e-18      uc=7.2440e-11 \
u0=4.4700e+02 \
   dsub=5.0000e-01    eta0=5.1580e-02    etab=-6.600e-02 \
nfactor=1.0000e+00 \
     em=4.1000e+07    pclm=1.2650e+00 \
  drout=5.0000e-01 \
     a0=1.7080e+00      a1=0.0000e+00      a2=1.0000e+00 \
   pvag=3.1500e-01    vsat=9.4190e+04     ags=3.1620e-01      b0=2.6240e-08      b1=0.0000e+00 \
  delta=1.0000e-03 pdiblcb=3.6000e-01 \
pdiblc1=1.2970e-01 pdiblc2=1.9500e-03 \
     w0=2.5000e-06 \
    dlc=3.0000e-08 \
    dwc=9.5120e-08     dwb=0.0000e+00     dwg=-7.686e-09 \
     ll=6.3200e-15      lw=0.0000e+00     lwl=0.0000e+00 \
    lln=1.0000e+00     lwn=1.0000e+00      wl=0.0000e+00 \
     ww=-2.855e-14     wwl=-4.365e-21     wln=1.0000e+00 \
     wr=1.0000e+00     wwn=1.0000e+00 \
     at=1.0000e+04     ute=-1.700e+00 \
    kt1=-3.400e-01     kt2=-4.840e-02    kt1l=0.0000e+00 \
    ua1=0.0000e+00     ub1=0.0000e+00     uc1=0.0000e+00 \
    prt=0.0000e+00 \
   cgso=1.2000e-11    cgdo=1.2000e-11    cgbo=1.1000e-10 \
   cgdl=3.5000e-10    cgsl=3.5000e-10  ckappa=1.7010e+00 \
     cf=0.0000e+00     elm=5.0000e+00 \
  xpart=1.0000e+00     clc=1.0000e-15     cle=6.0000e-01 \
\
   rdsw=4.4670e+02 \
   cdsc=1.0000e-09   cdscb=0.0000e+00   cdscd=0.0000e+00 \
   prwb=0.0000e+00    prwg=1.9050e-02     cit=0.0000e+00 \
tox=7.6700e-09 \
  ngate=0.0000e+00 \
    nlx=1.4300e-07 \
     xl=0.0000e+00      xw=0.0000e+00 \
     af=1.6120e+00      kf=6.1730e-26      ef=1.0000e+00 \
   noia=1.0040e+19    noib=6.7940e+04    noic=-1.274e-12 \
     rd=0.0000e+00      rs=0.0000e+00     rsh=7.5000e+01 \
   minr=1.000e-03 \
    rdc=0.0000e+00     rsc=0.0000e+00 lint=-6.902e-09 \
wint=9.5120e-08   ldif=0.000e+00    hdif=8.0000e-07 \
     xj=3.0000e-07      js=5.1000e-07 \
      n=1.0000e+00 \
  dskip=no          tlev=0           tlevc=0         \
    jsw=6.0000e-13 \
     cj=8.3000e-04    cjsw=2.5000e-10 \
     fc=0.0000e+00    fcsw=0.000e+00 \
     mj=3.4000e-01    mjsw=2.3000e-01 \
     pb=6.9000e-01    pbsw=6.9000e-01     xti=2.0300e+00
ends modnl

// ----------------------------------------------------------------------

// ----------------------------------------------------------------------
// Owner: austriamicrosystems
// HIT-Kit: Digital
// ************************ SIMULATION PARAMETERS ************************
//  ----------------------------------------------------------------------
//  format    : Spectre (Spectre Direct)
//  model     : MOS BSIM3v3
//  process   : C35
//  revision  : 5.0;
//  extracted : B27167L1W5C45; 15-04-2007; bse (5866)
//  doc#      : Eng-182 REV_6
//  ----------------------------------------------------------------------
//                          TYPICAL MEAN CONDITION
//
//  ----------------------------------------------------------------------
//
inline subckt modnml ( d g s b )
parameters w=1.0e-6 l=1.0e-6 nrd=0.0 nrs=0.0 ad=0.0 as=0.0 pd=0.0 ps=0.0 ng=1
+ ws= w
+ ls= l
+ shk=1
//
if (modnml==1)
modnml ( d g s b ) mosinsub w=ws l=ls nrd=6.0000e-07/ws nrs=6.0000e-07/ws ad=ad as=as pd=pd ps=ps m=ng
else
modnml ( d s ) resistor r=1e30
notvalid paramtest errorif=(modnml==0) \
message="
***************************************************
*
* nmosml is not valid in selected process option.
*
***************************************************"
model mosinsub bsim3v3 version=3.2400e+00  type=n  capmod=2.0000e+00 \
 mobmod=1.0000e+00  nqsmod=0.0000e+00  noimod=3.0000e+00 \
   vbox=1.000e+03      k1=9.8000e-01 \
     k2=0.0000e+00      k3=-1.456e+00     k3b=-7.244e-01 \
    nch=1.4460e+17 vth0=5.7940e-01 \
   voff=-8.684e-02    dvt0=1.6010e+01    dvt1=1.0610e+00 \
   dvt2=4.5970e-02    keta=1.9180e-02 \
 pscbe1=1.0000e+30  pscbe2=1.0000e-06 \
 alpha0=1.6220e-08  alpha1=1.3800e-01   beta0=2.1000e+01 \
  dvt0w=0.0000e+00   dvt1w=3.0990e+06   dvt2w=4.5170e-02 \
     ua=1.0000e-12      ub=2.2910e-18      uc=6.9180e-11 \
u0=4.9000e+02 \
   dsub=5.0000e-01    eta0=5.1290e-02    etab=-5.126e-03 \
nfactor=9.6050e-01 \
     em=4.1000e+07    pclm=1.1380e+00 \
  drout=5.0000e-01 \
     a0=1.0460e+00      a1=0.0000e+00      a2=1.0000e+00 \
   pvag=5.0000e-02    vsat=8.4420e+04     ags=1.2000e-01      b0=0.0000e+00      b1=0.0000e+00 \
  delta=1.8640e-03 pdiblcb=9.7980e-01 \
pdiblc1=6.1030e-06 pdiblc2=7.2440e-04 \
     w0=3.3160e-08 \
    dlc=1.0000e-07 \
    dwc=1.1660e-07     dwb=5.8200e-09     dwg=-1.000e-09 \
     ll=-9.793e-15      lw=0.0000e+00     lwl=0.0000e+00 \
    lln=1.0000e+00     lwn=1.0000e+00      wl=0.0000e+00 \
     ww=-4.017e-14     wwl=-1.380e-21     wln=1.0000e+00 \
     wr=1.0000e+00     wwn=1.0000e+00 \
     at=4.3550e+04     ute=-1.720e+00 \
    kt1=-4.500e-01     kt2=-6.560e-02    kt1l=0.0000e+00 \
    ua1=2.7540e-10     ub1=0.0000e+00     uc1=0.0000e+00 \
    prt=2.0000e+02 \
   cgso=1.0000e-12    cgdo=1.0000e-12    cgbo=1.1000e-10 \
   cgdl=4.3400e-10    cgsl=4.3400e-10  ckappa=1.9040e+00 \
     cf=0.0000e+00     elm=5.0000e+00 \
  xpart=1.0000e+00     clc=1.0000e-15     cle=6.0000e-01 \
\
   rdsw=1.1940e+03 \
   cdsc=2.4000e-04   cdscb=-7.468e-04   cdscd=0.0000e+00 \
   prwb=5.2110e-02    prwg=-5.443e-02     cit=0.0000e+00 \
tox=1.5700e-08 \
  ngate=1.0000e+00 \
    nlx=2.3690e-07 \
     xl=0.0000e+00      xw=0.0000e+00 \
     af=1.5880e+00      kf=5.7540e-26      ef=1.0000e+00 \
   noia=1.5940e+19    noib=1.1070e+05    noic=-3.506e-12 \
     rd=0.0000e+00      rs=0.0000e+00     rsh=7.9000e+01 \
   minr=1.000e-03 \
    rdc=0.0000e+00     rsc=0.0000e+00 lint=1.1900e-07 \
wint=1.1660e-07   ldif=0.000e+00    hdif=6.0000e-07 \
     xj=3.0000e-07      js=5.1000e-07 \
      n=1.0000e+00 \
  dskip=no          tlev=0           tlevc=0         \
    jsw=6.0000e-13 \
     cj=8.3000e-04    cjsw=2.5000e-10 \
     fc=0.0000e+00    fcsw=0.000e+00 \
     mj=3.4000e-01    mjsw=2.3000e-01 \
     pb=6.9000e-01    pbsw=6.9000e-01     xti=2.0300e+00
ends modnml

// ----------------------------------------------------------------------
// ----------------------------------------------------------------------
// Owner: austriamicrosystems
// HIT-Kit: Digital
// ************************ SIMULATION PARAMETERS ************************
//  ----------------------------------------------------------------------
//  format    : Spectre (Spectre Direct)
//  model     : MOS BSIM3v3
//  process   : C35
//  revision  : 4.1;
//  extracted : C64685 ; 2002-12; ese(5487)
//  doc#      : ENG-182 REV_6
//  ----------------------------------------------------------------------
//                          TYPICAL MEAN CONDITION
//
//  ----------------------------------------------------------------------
//
inline subckt modpm ( d g s b )
parameters w=1.0e-6 l=1.0e-6 nrd=0.0 nrs=0.0 ad=0.0 as=0.0 pd=0.0 ps=0.0 ng=1
+ ws= w
+ ls= l
+ shk=1
//
if (modpm==1)
modpm ( d g s b ) mosinsub w=ws l=ls nrd=nrd nrs=nrs ad=ad as=as pd=pd ps=ps m=ng
else
modpm ( d s ) resistor r=1e30
notvalid paramtest errorif=(modpm==0) \
message="
***************************************************
*
* pmosm is not valid in selected process option.
*
***************************************************"
model mosinsub bsim3v3 version=3.2400e+00  type=p  capmod=2.0000e+00 \
 mobmod=1.0000e+00  nqsmod=0.0000e+00  noimod=3 \
   vbox=1.000e+03      k1=5.4907e-01 \
     k2=4.6395e-02      k3=8.3170e+00     k3b=-1.479e+00 \
    nch=8.4790e+16 vth0=-1.011e+00 \
   voff=-1.148e-01    dvt0=5.3990e-01    dvt1=4.1120e-01 \
   dvt2=-9.479e-02    keta=3.0100e-02 \
 pscbe1=1.0000e+30  pscbe2=1.0000e-06 \
 alpha0=2.7100e-07  alpha1=1.9100e+00   beta0=3.4770e+01 \
  dvt0w=8.0990e-01   dvt1w=1.4800e+05   dvt2w=4.4040e-02 \
     ua=1.8000e-12      ub=2.2180e-18      uc=-7.278e-11 \
u0=1.3730e+02 \
   dsub=5.0000e-01    eta0=9.7360e-02    etab=-2.948e-02 \
nfactor=7.0460e-01 \
     em=4.1000e+07    pclm=4.3950e+00 \
  drout=5.0000e-01 \
     a0=1.3860e+00      a1=0.0000e+00      a2=1.0000e+00 \
   pvag=0.0000e+00    vsat=1.4360e+05     ags=1.3640e-01      b0=1.9910e-08      b1=0.0000e+00 \
  delta=1.0000e-02 pdiblcb=1.0000e+00 \
pdiblc1=2.0370e-02 pdiblc2=1.0000e-20 \
     w0=1.0000e-10 \
    dlc=2.5000e-08 \
    dwc=6.2030e-08     dwb=0.0000e+00     dwg=0.0000e+00 \
     ll=0.000e+00      lw=0.000e+00     lwl=0.000e+00 \
    lln=1.000e+00     lwn=1.000e+00      wl=0.0000e+00 \
     ww=-9.750e-16     wwl=-1.787e-21     wln=1.0000e+00 \
     wr=1.0000e+00     wwn=1.0400e+00 \
     at=3.3000e+04     ute=-1.300e+00 \
    kt1=-6.003e-01     kt2=2.2000e-02    kt1l=0.0000e+00 \
    ua1=0.0000e+00     ub1=0.0000e+00     uc1=0.0000e+00 \
    prt=0.0000e+00 \
   cgso=9.1000e-11    cgdo=9.1000e-11    cgbo=1.1000e-10 \
   cgdl=6.0000e-11    cgsl=6.0000e-11  ckappa=6.0000e-01 \
     cf=0.0000e+00     elm=5.0000e+00 \
  xpart=1.0000e+00     clc=1.0000e-15     cle=6.0000e-01 \
   noff=1.0000e+00  voffcv=0.0000e+00 \
   rdsw=1.6230e+03 \
   cdsc=1.2140e-03   cdscb=2.9450e-04   cdscd=0.0000e+00 \
   prwb=-4.521e-01    prwg=0.0000e+00     cit=5.2590e-05 \
tox=1.4500e-08 \
  ngate=0.0000e+00 \
    nlx=2.2310e-07 \
     xl=0.0000e+00      xw=0.0000e+00 \
     af=1.6380e+00      kf=3.6250e-26      ef=1.0000e+00 \
   noia=5.8460e+17    noib=6.6230e+03    noic=7.7590e-13 \
     rd=0.0000e+00      rs=0.0000e+00     rsh=1.3000e+02 \
   minr=1.000e-03 \
    rdc=0.0000e+00     rsc=0.0000e+00 lint=-8.504e-08 \
wint=6.2030e-08   ldif=0.000e+00    hdif=6.0000e-07 \
     xj=3.0000e-07      js=2.8000e-07 \
      n=1.0000e+00 \
  dskip=no          tlev=0           tlevc=0         \
    jsw=3.7000e-13 \
     cj=1.3600e-03    cjsw=3.5000e-10 \
     fc=0.0000e+00    fcsw=0.000e+00 \
     mj=5.4000e-01    mjsw=4.6000e-01 \
     pb=1.0200e+00    pbsw=1.0200e+00     xti=1.9700e+00
ends modpm

// ----------------------------------------------------------------------

// ----------------------------------------------------------------------
// Owner: austriamicrosystems
// HIT-Kit: Digital
// ************************ SIMULATION PARAMETERS ************************
//  ----------------------------------------------------------------------
//  format    : Spectre (Spectre Direct)
//  model     : MOS BSIM3v3
//  process   : C35
//  revision  : 5.0;
//  extracted : B27167L1W5C45; 15-04-2007; bse (5866)
//  doc#      : Eng-182 REV_6
//  ----------------------------------------------------------------------
//                          TYPICAL MEAN CONDITION
//
//  ----------------------------------------------------------------------
//
inline subckt modpml ( d g s b )
parameters w=1.0e-6 l=1.0e-6 nrd=0.0 nrs=0.0 ad=0.0 as=0.0 pd=0.0 ps=0.0 ng=1
+ ws= w
+ ls= l
+ shk=1
//
if (modpml==1)
modpml ( d g s b ) mosinsub w=ws l=ls nrd=6.0000e-07/ws nrs=6.0000e-07/ws ad=ad as=as pd=pd ps=ps m=ng
else
modpml ( d s ) resistor r=1e30
notvalid paramtest errorif=(modpml==0) \
message="
***************************************************
*
* pmosml is not valid in selected process option.
*
***************************************************"
model mosinsub bsim3v3 version=3.2400e+00  type=p  capmod=2.0000e+00 \
 mobmod=1.0000e+00  nqsmod=0.0000e+00  noimod=3.0000e+00 \
   vbox=1.000e+03      k1=6.7600e-01 \
     k2=-4.000e-03      k3=1.7420e+01     k3b=-1.738e+00 \
    nch=6.7780e+16 vth0=-6.880e-01 \
   voff=-1.960e-01    dvt0=1.0000e+00    dvt1=4.2050e-01 \
   dvt2=-4.410e-02    keta=6.0000e-03 \
 pscbe1=1.0000e+30  pscbe2=1.0000e-06 \
 alpha0=1.3000e-07  alpha1=3.3320e-02   beta0=2.4820e+01 \
  dvt0w=5.7320e-01   dvt1w=2.8750e+05   dvt2w=1.6680e-01 \
     ua=3.3110e-09      ub=1.0000e-19      uc=-8.710e-11 \
u0=2.3600e+02 \
   dsub=5.0000e-01    eta0=1.2500e-01    etab=-3.726e-04 \
nfactor=1.0210e+00 \
     em=4.1000e+07    pclm=2.5000e+00 \
  drout=5.0000e-01 \
     a0=1.1720e+00      a1=-1.581e-01      a2=1.0000e+00 \
   pvag=0.0000e+00    vsat=1.5690e+05     ags=1.4450e-01      b0=6.1800e-08      b1=0.0000e+00 \
  delta=2.9180e-02 pdiblcb=8.4520e-01 \
pdiblc1=1.1270e-02 pdiblc2=1.2500e-03 \
     w0=1.3800e-06 \
    dlc=4.5000e-08 \
    dwc=1.2300e-07     dwb=5.5110e-09     dwg=-5.171e-09 \
     ll=0.0000e+00      lw=0.0000e+00     lwl=0.0000e+00 \
    lln=1.0000e+00     lwn=1.0000e+00      wl=0.0000e+00 \
     ww=-4.460e-14     wwl=0.0000e+00     wln=1.0000e+00 \
     wr=1.0000e+00     wwn=1.0000e+00 \
     at=3.0000e+03     ute=-1.628e+00 \
    kt1=-6.603e-01     kt2=-8.840e-02    kt1l=0.0000e+00 \
    ua1=-2.399e-09     ub1=0.0000e+00     uc1=0.0000e+00 \
    prt=0.0000e+00 \
   cgso=6.4000e-11    cgdo=6.4000e-11    cgbo=1.1000e-10 \
   cgdl=1.6000e-10    cgsl=1.6000e-10  ckappa=1.4370e+00 \
     cf=0.0000e+00     elm=5.0000e+00 \
  xpart=1.0000e+00     clc=1.0000e-15     cle=6.0000e-01 \
\
   rdsw=6.3530e+02 \
   cdsc=1.4540e-04   cdscb=-2.792e-05   cdscd=0.0000e+00 \
   prwb=-3.097e-01    prwg=0.0000e+00     cit=0.0000e+00 \
tox=1.5700e-08 \
  ngate=1.0000e+00 \
    nlx=2.9510e-07 \
     xl=0.0000e+00      xw=0.0000e+00 \
     af=1.5420e+00      kf=8.4060e-27      ef=1.0000e+00 \
   noia=3.1380e+18    noib=4.7230e+03    noic=5.0080e-13 \
     rd=0.0000e+00      rs=0.0000e+00     rsh=1.3000e+02 \
   minr=1.000e-03 \
    rdc=0.0000e+00     rsc=0.0000e+00 lint=-7.553e-08 \
wint=1.2300e-07   ldif=0.000e+00    hdif=6.0000e-07 \
     xj=3.0000e-07      js=2.8000e-07 \
      n=1.0000e+00 \
  dskip=no          tlev=0           tlevc=0         \
    jsw=3.7000e-13 \
     cj=1.3600e-03    cjsw=3.5000e-10 \
     fc=0.0000e+00    fcsw=0.000e+00 \
     mj=5.4000e-01    mjsw=4.6000e-01 \
     pb=1.0200e+00    pbsw=1.0200e+00     xti=1.9700e+00
ends modpml

// ----------------------------------------------------------------------
//----------------------------------------------------------------------
//************************* SIMULATION PARAMETERS ************************
// ----------------------------------------------------------------------
// format    : Spectre ( Spectre Direct )
// model     : DIODE
// process   : C35
// revision  : 4.0;
// extracted : B10866 ; 2002-12; ese(5487)
// doc#      : ENG-182 REV_6
// ----------------------------------------------------------------------
//                         TYPICAL MEAN CONDITION
// ----------------------------------------------------------------------
// TERMINALS: A=anode=P-region C=cathode=N-region
// VARIABLES: M (mulitiplier), AREA [m^2], PERI [m].
// NOTE: The role of a protection DIODE is to conduct ESD current to VDD
// (or from VSS). This forward bias is NOT modelled, only leakage current
// and capacitance during normal operation. Any inductive load etc that
// will give forward bias, must be limited by other components to within
// Operating Conditions, otherwise parasitic bipolar action can occur.
//
// Parameters: area perim
//
inline subckt nd ( a c )
parameters area=1.0e-12 perimeter=1.0e-6
//
if (subdiode==1)
nd ( a c ) diodeinsub area=area perim=perimeter region=off
else
nd ( a c ) resistor r=1e30
notvalid paramtest errorif=(subdiode==0) \
message="
***************************************************
*
* subdiode is not valid in selected process option.
*
***************************************************"
model diodeinsub diode level=1 dskip=no \
     is=5.1000e-07     isw=6.0000e-13       n=1.0000e+00      ns=1.0000e+00 \
   minr=0.100e+00    imax=(1.000e+00/area) \
    cjo=8.4000e-04       m=3.4000e-01      vj=6.9000e-01      tt=0.000e+00 \
    xti=2.0260e+00 \
   cjsw=2.5000e-10    mjsw=2.3000e-01    vjsw=6.9000e-01      fc=0.000e+00 \
     af=1.000e+00      kf=0.000e+00
ends nd
// ----------------------------------------------------------------------
// Owner: austriamicrosystems
// HIT-Kit: Digital
// ************************ SIMULATION PARAMETERS ************************
//  ----------------------------------------------------------------------
//  format    : Spectre (Spectre Direct)
//  model     : MOS BSIM3v3
//  process   : C35
//  revision  : 4.1;
//  extracted : C64685 ; 2002-12; ese(5487)
//  doc#      : ENG-182 REV_6
//  ----------------------------------------------------------------------
//                          TYPICAL MEAN CONDITION
//
//  ----------------------------------------------------------------------
//
inline subckt modp ( d g s b )
parameters w=1.0e-6 l=1.0e-6 nrd=0.0 nrs=0.0 ad=0.0 as=0.0 pd=0.0 ps=0.0 ng=1 vthadd=0.0
+ ws= w
+ ls= l
+ shk=1
//
if (modp==1)
modp ( d g s b ) mosinsub w=ws l=ls nrd=nrd nrs=nrs ad=ad as=as pd=pd ps=ps m=ng
else
modp ( d s ) resistor r=1e30
notvalid paramtest errorif=(modp==0) \
message="
***************************************************
*
* pmos is not valid in selected process option.
*
***************************************************"
model mosinsub bsim3v3 version=3.2400e+00  type=p  capmod=2.0000e+00 \
 mobmod=1.0000e+00  nqsmod=0.0000e+00  noimod=3 \
   vbox=1.000e+03      k1=5.9959e-01 \
     k2=-6.038e-02      k3=1.1030e+01     k3b=-7.580e-01 \
    nch=9.2400e+16 vth0=-6.915e-01 + vthadd\
   voff=-1.170e-01    dvt0=1.6500e+00    dvt1=3.8680e-01 \
   dvt2=1.6590e-02    keta=-1.440e-02 \
 pscbe1=1.0000e+30  pscbe2=1.0000e-06 \
 alpha0=1.0000e-09  alpha1=1.5000e+00   beta0=3.2500e+01 \
  dvt0w=1.8790e-01   dvt1w=7.3350e+04   dvt2w=-6.312e-03 \
     ua=5.3940e-10      ub=1.0530e-18      uc=1.0000e-20 \
u0=1.4820e+02 \
   dsub=5.0000e-01    eta0=2.4800e-01    etab=-3.917e-03 \
nfactor=1.2140e+00 \
     em=4.1000e+07    pclm=3.1840e+00 \
  drout=5.0000e-01 \
     a0=5.8500e-01      a1=0.0000e+00      a2=1.0000e+00 \
   pvag=0.0000e+00    vsat=1.1580e+05     ags=2.4680e-01      b0=8.8320e-08      b1=0.0000e+00 \
  delta=1.0000e-02 pdiblcb=1.0000e+00 \
pdiblc1=1.0000e-04 pdiblc2=1.0000e-20 \
     w0=1.0000e-10 \
    dlc=2.4500e-08 \
    dwc=3.4490e-08     dwb=0.0000e+00     dwg=0.0000e+00 \
     ll=0.000e+00      lw=0.000e+00     lwl=0.000e+00 \
    lln=1.000e+00     lwn=1.000e+00      wl=0.0000e+00 \
     ww=1.8940e-16     wwl=-1.981e-21     wln=1.0000e+00 \
     wr=1.0000e+00     wwn=1.0400e+00 \
     at=3.3000e+04     ute=-1.300e+00 \
    kt1=-5.403e-01     kt2=2.2000e-02    kt1l=0.0000e+00 \
    ua1=0.0000e+00     ub1=0.0000e+00     uc1=0.0000e+00 \
    prt=0.0000e+00 \
   cgso=8.6000e-11    cgdo=8.6000e-11    cgbo=1.1000e-10 \
   cgdl=1.0800e-10    cgsl=1.0800e-10  ckappa=6.0000e-01 \
     cf=0.0000e+00     elm=5.0000e+00 \
  xpart=1.0000e+00     clc=1.0000e-15     cle=6.0000e-01 \
   noff=1.0000e+00  voffcv=0.0000e+00 \
   rdsw=1.0330e+03 \
   cdsc=2.5890e-03   cdscb=2.9430e-04   cdscd=4.3700e-04 \
   prwb=-9.731e-02    prwg=1.4770e-01     cit=0.0000e+00 \
tox=7.7540e-09 \
  ngate=0.0000e+00 \
    nlx=1.7700e-07 \
     xl=0.0000e+00      xw=0.0000e+00 \
     af=1.4610e+00      kf=1.1910e-26      ef=1.0000e+00 \
   noia=5.2450e+17    noib=4.8160e+03    noic=8.0360e-13 \
     rd=0.0000e+00      rs=0.0000e+00     rsh=1.2900e+02 \
   minr=1.000e-03 \
    rdc=0.0000e+00     rsc=0.0000e+00 lint=-7.130e-08 \
wint=3.4490e-08   ldif=0.000e+00    hdif=8.0000e-07 \
     xj=3.0000e-07      js=2.8000e-07 \
      n=1.0000e+00 \
  dskip=no          tlev=0           tlevc=0         \
    jsw=3.7000e-13 \
     cj=1.3600e-03    cjsw=3.5000e-10 \
     fc=0.0000e+00    fcsw=0.000e+00 \
     mj=5.4000e-01    mjsw=4.6000e-01 \
     pb=1.0200e+00    pbsw=1.0200e+00     xti=1.9730e+00
ends modp

// ----------------------------------------------------------------------

// ----------------------------------------------------------------------
// Owner: austriamicrosystems
// HIT-Kit: Digital
// ************************ SIMULATION PARAMETERS ************************
//  ----------------------------------------------------------------------
//  format    : Spectre (Spectre Direct)
//  model     : MOS BSIM3v3
//  process   : C35
//  revision  : 5.0;
//  extracted : B27167L1W5C45; 15-04-2007; bse (5866)
//  doc#      : Eng-182 REV_6
//  ----------------------------------------------------------------------
//                          TYPICAL MEAN CONDITION
//
//  ----------------------------------------------------------------------
//
inline subckt modpl ( d g s b )
parameters w=1.0e-6 l=1.0e-6 nrd=0.0 nrs=0.0 ad=0.0 as=0.0 pd=0.0 ps=0.0 ng=1
+ ws= w
+ ls= l
+ shk=1
//
if (modpl==1)
modpl ( d g s b ) mosinsub w=ws l=ls nrd=8.0000e-07/ws nrs=8.0000e-07/ws ad=ad as=as pd=pd ps=ps m=ng
else
modpl ( d s ) resistor r=1e30
notvalid paramtest errorif=(modpl==0) \
message="
***************************************************
*
* pmosl is not valid in selected process option.
*
***************************************************"
model mosinsub bsim3v3 version=3.2400e+00  type=p  capmod=2.0000e+00 \
 mobmod=1.0000e+00  nqsmod=0.0000e+00  noimod=3.0000e+00 \
   vbox=1.000e+03      k1=6.8800e-01 \
     k2=-7.790e-02      k3=5.2610e+01     k3b=7.2440e+00 \
    nch=7.8380e+16 vth0=-5.240e-01 \
   voff=-2.280e-01    dvt0=1.0460e+00    dvt1=3.9190e-01 \
   dvt2=1.9100e-03    keta=-2.400e-03 \
 pscbe1=1.0000e+30  pscbe2=1.0000e-06 \
 alpha0=1.1750e-08  alpha1=1.0000e-03   beta0=1.9580e+01 \
  dvt0w=1.0000e+00   dvt1w=5.3000e+06   dvt2w=9.5620e-02 \
     ua=1.0000e-12      ub=1.9050e-18      uc=6.3100e-11 \
u0=1.4500e+02 \
   dsub=5.0000e-01    eta0=1.9590e-01    etab=0.0000e+00 \
nfactor=1.5790e+00 \
     em=4.1000e+07    pclm=8.2410e-01 \
  drout=5.0000e-01 \
     a0=5.0000e-01      a1=0.0000e+00      a2=1.0000e+00 \
   pvag=0.0000e+00    vsat=9.8190e+04     ags=2.6300e-01      b0=6.0600e-08      b1=0.0000e+00 \
  delta=4.3330e-03 pdiblcb=9.6330e-01 \
pdiblc1=1.0000e-03 pdiblc2=1.3800e-03 \
     w0=1.9050e-06 \
    dlc=2.0000e-08 \
    dwc=7.2920e-08     dwb=1.6220e-08     dwg=0.0000e+00 \
     ll=0.0000e+00      lw=0.0000e+00     lwl=0.0000e+00 \
    lln=1.0000e+00     lwn=1.0000e+00      wl=0.0000e+00 \
     ww=-2.000e-14     wwl=0.0000e+00     wln=1.0000e+00 \
     wr=1.0000e+00     wwn=1.0400e+00 \
     at=3.3000e+04     ute=-1.280e+00 \
    kt1=-5.577e-01     kt2=-6.560e-02    kt1l=0.0000e+00 \
    ua1=0.0000e+00     ub1=0.0000e+00     uc1=0.0000e+00 \
    prt=0.0000e+00 \
   cgso=5.6000e-11    cgdo=5.6000e-11    cgbo=1.1000e-10 \
   cgdl=2.4000e-10    cgsl=2.4000e-10  ckappa=5.6400e-01 \
     cf=0.0000e+00     elm=5.0000e+00 \
  xpart=1.0000e+00     clc=1.0000e-15     cle=6.0000e-01 \
\
   rdsw=2.0890e+03 \
   cdsc=1.3750e-03   cdscb=4.4880e-04   cdscd=1.9130e-04 \
   prwb=3.8020e-02    prwg=-1.047e-01     cit=0.0000e+00 \
tox=7.6600e-09 \
  ngate=1.0000e+00 \
    nlx=1.6220e-07 \
     xl=0.0000e+00      xw=0.0000e+00 \
     af=1.4350e+00      kf=4.0400e-27      ef=1.0000e+00 \
   noia=8.0890e+18    noib=1.5690e+03    noic=4.6050e-13 \
     rd=0.0000e+00      rs=0.0000e+00     rsh=1.2900e+02 \
   minr=1.000e-03 \
    rdc=0.0000e+00     rsc=0.0000e+00 lint=-1.285e-08 \
wint=7.2920e-08   ldif=0.000e+00    hdif=8.0000e-07 \
     xj=3.0000e-07      js=2.8000e-07 \
      n=1.0000e+00 \
  dskip=no          tlev=0           tlevc=0         \
    jsw=3.7000e-13 \
     cj=1.3600e-03    cjsw=3.5000e-10 \
     fc=0.0000e+00    fcsw=0.000e+00 \
     mj=5.4000e-01    mjsw=4.6000e-01 \
     pb=1.0200e+00    pbsw=1.0200e+00     xti=1.9700e+00
ends modpl

// ----------------------------------------------------------------------
//----------------------------------------------------------------------
//************************* SIMULATION PARAMETERS ************************
// ----------------------------------------------------------------------
// format    : Spectre ( Spectre Direct )
// model     : DIODE
// process   : C35
// revision  : 4.1;
// extracted : C64685 ; 2002-12; ese(5487)
// doc#      : ENG-182 REV_6
// ----------------------------------------------------------------------
//                         TYPICAL MEAN CONDITION
// ----------------------------------------------------------------------
// TERMINALS: A=anode=P-region C=cathode=N-region
// VARIABLES: M (mulitiplier), AREA [m^2], PERI [m].
// NOTE: The role of a protection DIODE is to conduct ESD current to VDD
// (or from VSS). This forward bias is NOT modelled, only leakage current
// and capacitance during normal operation. Any inductive load etc that
// will give forward bias, must be limited by other components to within
// Operating Conditions, otherwise parasitic bipolar action can occur.
//
// Parameters: area perim
//
inline subckt pd ( a c )
parameters area=1.0e-12 perimeter=1.0e-6
//
if (welldiode==1)
pd ( a c ) diodeinsub area=area perim=perimeter region=off
else
pd ( a c ) resistor r=1e30
notvalid paramtest errorif=(welldiode==0) \
message="
***************************************************
*
* welldiode is not valid in selected process option.
*
***************************************************"
model diodeinsub diode level=1 dskip=no \
     is=2.8000e-07     isw=3.7000e-13       n=1.0000e+00      ns=1.0000e+00 \
   minr=0.100e+00    imax=(1.000e+00/area) \
    cjo=1.3600e-03       m=5.4000e-01      vj=1.0200e+00      tt=0.000e+00 \
    xti=1.9730e+00 \
   cjsw=3.5000e-10    mjsw=4.6000e-01    vjsw=1.0200e+00      fc=0.000e+00 \
     af=1.000e+00      kf=0.000e+00
ends pd
// ----------------------------------------------------------------------
// Owner: austriamicrosystems
// HIT-Kit: Digital
// ************************ SIMULATION PARAMETERS ************************
//  ----------------------------------------------------------------------
//  format    : Spectre (Spectre Direct)
//  model     : MOS BSIM3v3
//  process   : C35
//  revision  : 4.1;
//  extracted : C35 B11004.L2; 2002-11; hhl(5481)
//  doc#      : Eng-182  REV_6.0
//  ----------------------------------------------------------------------
//                         TYPICAL MEAN CONDITION
//  ----------------------------------------------------------------------
//  HV-TRANSISTOR
//  ----------------------------------------------------------------------
inline subckt modnmh ( d g s b )
// Parameters: w l nrd nrs ad as pd ps
parameters w=1.0e-6 l=1.0e-6 nrd=0.0 nrs=0.0 ad=0.0 as=0.0 pd=0.0 ps=0.0 mult=1
+ ws=w
+ ls=l
+ dvthmat=mv_modnmh*(1.03e-08/sqrt(ls*ws*mult)) dumat=mu_modnmh*(3.5e-9/sqrt(ls*ws*mult))
//
if (modnmh==1){
modnmh ( d1 g s b ) mosinsub w=ws l=ls nrd=0 nrs=6.0000e-07/ws ad=ad as=as pd=pd ps=ps
rd ( d1 d ) resistor r=(1.5470e+03*4.0000e-06/(ws)) tc1=6.2000e-03
}else
modnmh ( d s ) resistor r=1e30
notvalid paramtest errorif=(modnmh==0) \
message="
***************************************************
*
* nmosmh is not valid in selected process option.
*
***************************************************"
//
model mosinsub bsim3v3 version=3.1 type=n  capmod=2.0000e+00 \
 mobmod=1.0000e+00  nqsmod=0.0000e+00  noimod=3 \
   vbox=1.000e+03      k1=9.5409e-01 \
     k2=4.9101e-02      k3=-2.439e+00     k3b=4.0770e-01 \
    nch=2.0920e+17 vth0=6.4490e-01 \
   voff=-4.948e-02    dvt0=4.9850e+01    dvt1=1.6830e+00 \
   dvt2=4.1260e-02    keta=-7.397e-02 \
 pscbe1=4.0000e+10  pscbe2=1.0000e-10 \
 alpha0=0.0000e+00   beta0=3.0000e+01 \
  dvt0w=0.0000e+00   dvt1w=0.0000e+00   dvt2w=0.0000e+00 \
     ua=1.0000e-12      ub=3.7680e-19      uc=6.3910e-12 \
u0=4.3940e+02 \
   dsub=5.0000e-01    eta0=1.6160e-03    etab=-1.373e-02 \
nfactor=3.4550e-01 \
     em=4.1000e+07    pclm=1.0550e-01 \
  drout=5.0000e-01 \
     a0=2.1900e-01      a1=0.0000e+00      a2=1.0000e+00 \
   pvag=0.0000e+00    vsat=5.1290e+04     ags=9.4480e-02      b0=-3.629e-08      b1=0.0000e+00 \
  delta=3.3700e-03 pdiblcb=3.8720e-01 \
pdiblc1=1.0000e-10 pdiblc2=1.0000e-10 \
     w0=6.2890e-08 \
    dlc=8.9170e-08 \
    dwc=4.9380e-08     dwb=0.0000e+00     dwg=0.0000e+00 \
     ll=0.0000e+00      lw=0.0000e+00     lwl=0.0000e+00 \
    lln=1.0000e+00     lwn=1.0000e+00      wl=0.0000e+00 \
     ww=0.0000e+00     wwl=0.0000e+00     wln=1.0000e+00 \
    wwn=1.0000e+00 \
   tnom=2.7000e+01      at=3.3000e+04     ute=-1.760e+00 \
    kt1=-4.502e-01     kt2=2.2000e-02    kt1l=0.0000e+00 \
    ua1=0.0000e+00     ub1=0.0000e+00     uc1=0.0000e+00 \
    prt=0.0000e+00 \
   cgso=1.0800e-10    cgdo=1.0800e-10    cgbo=1.1000e-10 \
   cgdl=0.0000e+00    cgsl=0.0000e+00  ckappa=6.0000e-01 \
     cf=0.0000e+00     elm=5.0000e+00 \
  xpart=1.0000e+00     clc=1.0000e-15     cle=6.0000e-01 \
\
   rdsw=5.3040e+02 \
   cdsc=1.0000e-02   cdscb=0.0000e+00   cdscd=8.4480e-05 \
   prwb=0.0000e+00    prwg=0.0000e+00     cit=8.1220e-04 \
tox=1.5140e-08 \
  ngate=0.0000e+00 \
    nlx=1.5930e-07 \
     xl=-1.050e-06      xw=0.0000e+00 \
     af=1.6290e+00      kf=9.1800e-26      ef=1.0000e+00 \
   noia=2.2450e+19    noib=1.1680e+05    noic=-1.680e-12 \
     rd=0.0000e+00      rs=0.0000e+00     rsh=7.9460e+01 \
   minr=1.000e-03 \
    rdc=0.0000e+00     rsc=0.0000e+00 lint=8.9170e-08 \
wint=4.9380e-08   ldif=0.000e+00    hdif=6.0000e-07 \
     xj=3.0000e-07      js=5.1000e-07 \
      n=1.0000e+00 \
  dskip=no          tlev=0           tlevc=0         \
    jsw=6.0000e-13 \
     cj=8.0000e-05    cjsw=5.1000e-10 \
     fc=0.0000e+00    fcsw=0.000e+00 \
     mj=3.9000e-01    mjsw=2.7000e-01 \
     pb=5.3000e-01    pbsw=6.9000e-01     xti=2.0260e+00
ends modnmh
// ----------------------------------------------------------------------
// Owner: austriamicrosystems
// HIT-Kit: Digital
// ************************ SIMULATION PARAMETERS ************************
//  ----------------------------------------------------------------------
//  format    : Spectre (Spectre Direct)
//  model     : MOS BSIM3v3
//  process   : c35
//  revision  : 4.1;
//  extracted : Wafer B26654W01 2005/10/10 REVISION 4.0; wpc(5481)
//  doc#      : Eng-182  REV 6.0
//  ----------------------------------------------------------------------
//                         TYPICAL MEAN CONDITION
//  ----------------------------------------------------------------------
//  HV-TRANSISTOR
//  ----------------------------------------------------------------------
inline subckt modnmhl ( d g s b )
// Parameters: w l nrd nrs ad as pd ps
parameters w=1.0e-6 l=1.0e-6 nrd=0.0 nrs=0.0 ad=0.0 as=0.0 pd=0.0 ps=0.0 mult=1
+ ws=w
+ ls=l
+ dvthmat=mv_modnmhl*(0.95e-08/sqrt(ls*ws*mult)) dumat=mu_modnmhl*(3.5e-9/sqrt(ls*ws*mult))
//
if (modnmhl==1){
modnmhl ( d1 g s b ) mosinsub w=ws l=ls nrd=0 nrs=8.0000e-07/ws ad=ad as=as pd=pd ps=ps
rd ( d1 d ) resistor r=(1.5080e+03*4.0000e-06/(ws+(0.0000e+00))) tc1=6.2000e-03
}else
modnmhl ( d s ) resistor r=1e30
notvalid paramtest errorif=(modnmhl==0) \
message="
***************************************************
*
* nmosmhl is not valid in selected process option.
*
***************************************************"
//
model mosinsub bsim3v3 version=3.1 type=n  capmod=2.0000e+00 \
 mobmod=1.0000e+00  nqsmod=0.0000e+00  noimod=3 \
   vbox=1.000e+03      k1=7.5005e-01 \
     k2=5.8718e-02      k3=0.0000e+00     k3b=0.0000e+00 \
    nch=1.4400e+17 vth0=4.9500e-01 \
   voff=-5.565e-02    dvt0=0.0000e+00    dvt1=1.6830e+00 \
   dvt2=4.1260e-02    keta=-8.210e-02 \
 pscbe1=4.0000e+10  pscbe2=1.0000e-10 \
 alpha0=0.0000e+00   beta0=3.0000e+01 \
  dvt0w=0.0000e+00   dvt1w=0.0000e+00   dvt2w=0.0000e+00 \
     ua=2.2380e-10      ub=0.0000e+00      uc=-1.429e-11 \
u0=5.1100e+02 \
   dsub=5.0000e-01    eta0=1.6160e-03    etab=-1.373e-02 \
nfactor=8.5500e-01 \
     em=4.1000e+07    pclm=1.0550e-01 \
  drout=5.0000e-01 \
     a0=4.7540e-02      a1=0.0000e+00      a2=1.0000e+00 \
   pvag=0.0000e+00    vsat=5.2060e+04     ags=-3.227e-01      b0=0.0000e+00      b1=0.0000e+00 \
  delta=1.5850e-02 pdiblcb=3.8720e-01 \
pdiblc1=1.0000e-10 pdiblc2=1.0000e-10 \
     w0=0.0000e+00 \
    dlc=0.0000e+00 \
    dwc=0.0000e+00     dwb=0.0000e+00     dwg=0.0000e+00 \
     ll=0.0000e+00      lw=0.0000e+00     lwl=0.0000e+00 \
    lln=1.0000e+00     lwn=1.0000e+00      wl=0.0000e+00 \
     ww=0.0000e+00     wwl=0.0000e+00     wln=1.0000e+00 \
    wwn=1.0000e+00 \
     at=3.3000e+04     ute=-1.720e+00 \
    kt1=-4.202e-01     kt2=2.2000e-02    kt1l=0.0000e+00 \
    ua1=0.0000e+00     ub1=0.0000e+00     uc1=0.0000e+00 \
    prt=0.0000e+00 \
   cgso=1.0000e-10    cgdo=1.0000e-10    cgbo=1.1000e-10 \
   cgdl=0.0000e+00    cgsl=0.0000e+00  ckappa=6.0000e-01 \
     cf=0.0000e+00     elm=5.0000e+00 \
  xpart=1.0000e+00     clc=1.0000e-15     cle=6.0000e-01 \
\
   rdsw=5.3040e+02 \
   cdsc=0.0000e+00   cdscb=0.0000e+00   cdscd=0.0000e+00 \
   prwb=0.0000e+00    prwg=0.0000e+00     cit=2.9310e-05 \
tox=1.5420e-08 \
  ngate=0.0000e+00 \
    nlx=1.5930e-07 \
     xl=0.0000e+00      xw=0.0000e+00 \
     af=1.5880e+00      kf=5.7540e-26      ef=1.0000e+00 \
   noia=1.5940e+19    noib=1.1070e+05    noic=-3.506e-12 \
     rd=0.0000e+00      rs=0.0000e+00     rsh=7.5000e+01 \
   minr=1.000e-03 \
    rdc=0.0000e+00     rsc=0.0000e+00 lint=6.0000e-07 \
wint=0.0000e+00   ldif=0.000e+00    hdif=8.0000e-07 \
     xj=3.0000e-07      js=5.1000e-07 \
      n=1.0000e+00 \
  dskip=no          tlev=0           tlevc=0         \
    jsw=6.0000e-13 \
     cj=8.3000e-04    cjsw=2.5000e-10 \
     fc=0.0000e+00    fcsw=0.000e+00 \
     mj=3.4000e-01    mjsw=2.3000e-01 \
     pb=6.9000e-01    pbsw=6.9000e-01     xti=2.0300e+00
ends modnmhl
// ----------------------------------------------------------------------
// Owner: austriamicrosystems
// HIT-Kit: Digital
// ************************ SIMULATION PARAMETERS ************************
//  ----------------------------------------------------------------------
//  format    : Spectre (Spectre Direct)
//  model     : MOS BSIM3v3
//  process   : C35
//  revision  : 4.1;
//  extracted : C35 B11004.L2; 2002-11; hhl(5481)
//  doc#      : Eng-182  REV_6.0
//  ----------------------------------------------------------------------
//                         TYPICAL MEAN CONDITION
//  ----------------------------------------------------------------------
//  HV-TRANSISTOR
//  ----------------------------------------------------------------------
inline subckt modnh ( d g s b )
// Parameters: w l nrd nrs ad as pd ps
parameters w=1.0e-6 l=1.0e-6 nrd=0.0 nrs=0.0 ad=0.0 as=0.0 pd=0.0 ps=0.0 mult=1
+ ws=w
+ ls=l
+ dvthmat=mv_modnh*(0.67e-08/sqrt(ls*ws*mult)) dumat=mu_modnh*(4.9e-9/sqrt(ls*ws*mult))
//
if (modnh==1){
modnh ( d1 g s b ) mosinsub w=ws l=ls nrd=0 nrs=6.0000e-07/ws ad=ad as=as pd=pd ps=ps
rd ( d1 d ) resistor r=(1.3280e+03*4.0000e-06/(ws)) tc1=6.2000e-03
}else
modnh ( d s ) resistor r=1e30
notvalid paramtest errorif=(modnh==0) \
message="
***************************************************
*
* nmosh is not valid in selected process option.
*
***************************************************"
//
model mosinsub bsim3v3 version=3.1 type=n  capmod=2.0000e+00 \
 mobmod=1.0000e+00  nqsmod=0.0000e+00  noimod=3 \
   vbox=1.000e+03      k1=6.2697e-01 \
     k2=-4.966e-03      k3=-2.240e+00     k3b=6.9540e-01 \
    nch=2.2360e+17 vth0=4.4600e-01 \
   voff=-5.090e-02    dvt0=4.9850e+01    dvt1=1.2960e+00 \
   dvt2=1.3110e-02    keta=-4.553e-02 \
 pscbe1=1.0000e+10  pscbe2=1.0240e-05 \
 alpha0=0.0000e+00   beta0=3.0000e+01 \
  dvt0w=0.0000e+00   dvt1w=0.0000e+00   dvt2w=0.0000e+00 \
     ua=1.0000e-30      ub=1.9490e-18      uc=1.2170e-10 \
u0=3.4270e+02 \
   dsub=5.0000e-01    eta0=3.0750e-02    etab=-5.261e-02 \
nfactor=2.0340e-01 \
     em=4.1000e+07    pclm=2.9400e-01 \
  drout=5.0000e-01 \
     a0=1.8930e-01      a1=0.0000e+00      a2=1.0000e+00 \
   pvag=0.0000e+00    vsat=2.4020e+05     ags=1.2450e-01      b0=6.7900e-08      b1=0.0000e+00 \
  delta=1.7290e-02 pdiblcb=2.0670e-01 \
pdiblc1=3.0900e-02 pdiblc2=6.3750e-04 \
     w0=1.1450e-07 \
    dlc=6.0000e-07 \
    dwc=2.6050e-08     dwb=0.0000e+00     dwg=0.0000e+00 \
     ll=0.0000e+00      lw=0.0000e+00     lwl=0.0000e+00 \
    lln=1.0000e+00     lwn=1.0000e+00      wl=0.0000e+00 \
     ww=0.0000e+00     wwl=0.0000e+00     wln=1.0000e+00 \
    wwn=1.0000e+00 \
   tnom=2.7000e+01      at=3.3000e+04     ute=-1.800e+00 \
    kt1=-3.302e-01     kt2=2.2000e-02    kt1l=0.0000e+00 \
    ua1=0.0000e+00     ub1=0.0000e+00     uc1=0.0000e+00 \
    prt=0.0000e+00 \
   cgso=1.2000e-10    cgdo=1.2000e-10    cgbo=1.1000e-10 \
   cgdl=0.0000e+00    cgsl=0.0000e+00  ckappa=6.0000e-01 \
     cf=0.0000e+00     elm=5.0000e+00 \
  xpart=1.0000e+00     clc=1.0000e-15     cle=6.0000e-01 \
\
   rdsw=1.0920e+03 \
   cdsc=7.9440e-03   cdscb=0.0000e+00   cdscd=8.4480e-05 \
   prwb=0.0000e+00    prwg=0.0000e+00     cit=1.0000e-03 \
tox=7.7000e-09 \
  ngate=0.0000e+00 \
    nlx=1.1320e-07 \
     xl=0.0000e+00      xw=0.0000e+00 \
     af=1.6290e+00      kf=9.1800e-26      ef=1.0000e+00 \
   noia=2.2450e+19    noib=1.1680e+05    noic=-1.680e-12 \
     rd=0.0000e+00      rs=0.0000e+00     rsh=8.2000e+01 \
   minr=1.000e-03 \
    rdc=0.0000e+00     rsc=0.0000e+00 lint=6.0000e-07 \
wint=2.6050e-08   ldif=0.000e+00    hdif=6.0000e-07 \
     xj=3.0000e-07      js=5.1000e-07 \
      n=1.0000e+00 \
  dskip=no          tlev=0           tlevc=0         \
    jsw=6.0000e-13 \
     cj=8.0000e-05    cjsw=5.1000e-10 \
     fc=0.0000e+00    fcsw=0.000e+00 \
     mj=3.9000e-01    mjsw=2.7000e-01 \
     pb=5.3000e-01    pbsw=6.9000e-01     xti=2.0260e+00
ends modnh
// ----------------------------------------------------------------------
// Owner: austriamicrosystems
// HIT-Kit: Digital
// ************************ SIMULATION PARAMETERS ************************
//  ----------------------------------------------------------------------
//  format    : Spectre (Spectre Direct)
//  model     : MOS BSIM3v3
//  process   : c35
//  revision  : 4.0;
//  extracted : Wafer B26654W01 2005/10/05 REVISION 4.0; wpc(5481)
//  doc#      : Eng-182  REV 6.0
//  ----------------------------------------------------------------------
//                         TYPICAL MEAN CONDITION
//  ----------------------------------------------------------------------
//  HV-TRANSISTOR
//  ----------------------------------------------------------------------
inline subckt modnhl ( d g s b )
// Parameters: w l nrd nrs ad as pd ps
parameters w=1.0e-6 l=1.0e-6 nrd=0.0 nrs=0.0 ad=0.0 as=0.0 pd=0.0 ps=0.0 mult=1
+ ws=w
+ ls=l
+ dvthmat=mv_modnhl*(0.67e-08/sqrt(ls*ws*mult)) dumat=mu_modnhl*(4.9e-9/sqrt(ls*ws*mult))
//
if (modnhl==1){
modnhl ( d1 g s b ) mosinsub w=ws l=ls nrd=0 nrs=8.0000e-07/ws ad=ad as=as pd=pd ps=ps
rd ( d1 d ) resistor r=(1.2030e+03*4.0000e-06/(ws+(0.0000e+00))) tc1=6.2000e-03
}else
modnhl ( d s ) resistor r=1e30
notvalid paramtest errorif=(modnhl==0) \
message="
***************************************************
*
* nmoshl is not valid in selected process option.
*
***************************************************"
//
model mosinsub bsim3v3 version=3.1 type=n  capmod=2.0000e+00 \
 mobmod=1.0000e+00  nqsmod=0.0000e+00  noimod=3 \
   vbox=1.000e+03      k1=5.0855e-01 \
     k2=-0.0000e+00      k3=0.0000e+00     k3b=0.0000e+00 \
    nch=1.5880e+17 vth0=3.6560e-01 \
   voff=-5.119e-02    dvt0=0.0000e+00    dvt1=1.2960e+00 \
   dvt2=1.3110e-02    keta=-3.955e-02 \
 pscbe1=1.0000e+10  pscbe2=1.0240e-05 \
 alpha0=0.0000e+00   beta0=3.0000e+01 \
  dvt0w=0.0000e+00   dvt1w=0.0000e+00   dvt2w=0.0000e+00 \
     ua=1.0000e-30      ub=1.9490e-18      uc=1.2170e-10 \
u0=3.4270e+02 \
   dsub=5.0000e-01    eta0=0.0000e+00    etab=0.0000e+00 \
nfactor=1.1530e+00 \
     em=4.1000e+07    pclm=2.9400e-01 \
  drout=5.0000e-01 \
     a0=3.3100e-01      a1=0.0000e+00      a2=1.0000e+00 \
   pvag=0.0000e+00    vsat=2.4020e+06     ags=3.2310e-01      b0=0.0000e+00      b1=0.0000e+00 \
  delta=3.1850e-02 pdiblcb=2.0670e-04 \
pdiblc1=3.0900e-02 pdiblc2=6.3750e-04 \
     w0=1.1450e-07 \
    dlc=0.0000e+00 \
    dwc=0.0000e+00     dwb=0.0000e+00     dwg=0.0000e+00 \
     ll=0.0000e+00      lw=0.0000e+00     lwl=0.0000e+00 \
    lln=1.0000e+00     lwn=1.0000e+00      wl=0.0000e+00 \
     ww=0.0000e+00     wwl=0.0000e+00     wln=1.0000e+00 \
    wwn=1.0000e+00 \
     at=3.3000e+04     ute=-1.700e+00 \
    kt1=-3.001e-01     kt2=2.2000e-02    kt1l=0.0000e+00 \
    ua1=0.0000e+00     ub1=0.0000e+00     uc1=0.0000e+00 \
    prt=0.0000e+00 \
   cgso=1.2000e-10    cgdo=1.2000e-10    cgbo=1.1000e-10 \
   cgdl=0.0000e+00    cgsl=0.0000e+00  ckappa=6.0000e-01 \
     cf=0.0000e+00     elm=5.0000e+00 \
  xpart=1.0000e+00     clc=1.0000e-15     cle=6.0000e-01 \
\
   rdsw=1.0920e+03 \
   cdsc=0.0000e+00   cdscb=0.0000e+00   cdscd=0.0000e+00 \
   prwb=0.0000e+00    prwg=0.0000e+00     cit=-2.050e-04 \
tox=7.6600e-09 \
  ngate=0.0000e+00 \
    nlx=1.1320e-07 \
     xl=0.0000e+00      xw=0.0000e+00 \
     af=1.5880e+00      kf=5.7540e-26      ef=1.0000e+00 \
   noia=1.5940e+19    noib=1.1070e+05    noic=-3.506e-12 \
     rd=0.0000e+00      rs=0.0000e+00     rsh=7.5000e+01 \
   minr=1.000e-03 \
    rdc=0.0000e+00     rsc=0.0000e+00 lint=6.0000e-07 \
wint=0.0000e+00   ldif=0.000e+00    hdif=8.0000e-07 \
     xj=3.0000e-07      js=5.1000e-07 \
      n=1.0000e+00 \
  dskip=no          tlev=0           tlevc=0         \
    jsw=6.0000e-13 \
     cj=8.3000e-04    cjsw=2.5000e-10 \
     fc=0.0000e+00    fcsw=0.000e+00 \
     mj=3.4000e-01    mjsw=2.3000e-01 \
     pb=6.9000e-01    pbsw=6.9000e-01     xti=2.0300e+00
ends modnhl
// ----------------------------------------------------------------------
// Owner: austriamicrosystems
// HIT-Kit: Digital
// ************************ SIMULATION PARAMETERS ************************
//  ----------------------------------------------------------------------
//  format    : Spectre (Spectre Direct)
//  model     : MOS BSIM3v3
//  process   : c35
//  revision  : ;
//  extracted : B58737.W09PE6; 2008-06; kmo(5966)
//  doc#      : ENG-327 Rev.2.0
//  ----------------------------------------------------------------------
//                         TYPICAL MEAN CONDITION
//  ----------------------------------------------------------------------
//  HV-TRANSISTOR
//  ----------------------------------------------------------------------
inline subckt modn30m ( d g s b )
// Parameters: w l nrd nrs ad as pd ps
parameters w=1.0e-6 l=1.0e-6 nrd=0.0 nrs=0.0 ad=0.0 as=0.0 pd=0.0 ps=0.0 mult=1 gv=(7.6860e-08/l + 9.1600e-01) dcdc=1
+ dvthmat=mv_modn30m*(0.56e-08/sqrt(l*w*mult)) dumat=mu_modn30m*(2.9e-9/sqrt(l*w*mult))
if (modn30m==1){
//
modn30m ( d1 g s1 b ) mosinsub w=w l=l nrd=0 nrs=8.0000e-07/w ad=0 as=as pd=0 ps=ps
rd ( d1 d ) resistor r=(9.9260e-01/(w+(1.6670e-06))) tc1=6.0000e-03
xj1 ( d gj d1 ) modn30mjfet1 w=w
xj2 ( d gj d1 ) modn30mjfet2 w=w
e1 ( d1 gj d1 s ) vcvs gain=gv min=-25 max=25
cgdx ( g d ) capacitor c=(3.5750e-10*w)
v1 ( s1 s ) vsource dc=0 type=dc
i1 ( d b ) bsource i=((6.1450e-10)/(l+(0.0000e+00))+(6.1590e-03))*i("v1:p")*(max((v(d,g)+(1.8290e-02)),1e-15))**(4.1480e+00)*exp((-1.4550e+01)/max((v(d,g)+(1.8290e-02)),1e-10))*(w+0.0000e+00)/w/(1+2.8000e+04*exp(7.7390e-03*i("v1:p")/(w+0.0000e+00)))
xdw ( b d1 ) modn30mnwd area=(1e-06*2.35*(w+1e-06*16)) perimeter=(4e-06*2.35+(w+1e-06*16))
}else
modn30m ( d s ) resistor r=1e30
notvalid paramtest errorif=(modn30m==0) \
message="
***************************************************
*
* nmos30m is not valid in selected process option.
*
***************************************************"
//
model mosinsub bsim3v3 version=3.1 type=n  capmod=2.0000e+00 \
 mobmod=1.0000e+00  nqsmod=0.0000e+00  noimod=3.0000e+00 \
   vbox=1.000e+03      k1=9.3509e-01 \
     k2=6.1371e-02      k3=2.3030e-01     k3b=-1.516e-02 \
    nch=2.1340e+17 vth0=7.0770e-01 \
   voff=-6.529e-02    dvt0=1.1390e-03    dvt1=1.0310e-01 \
   dvt2=-1.601e-01    keta=-1.236e-02 \
 pscbe1=3.5770e+12  pscbe2=5.7730e-12 \
 alpha0=0.0000e+00   beta0=3.0000e+01 \
  dvt0w=3.0490e-01   dvt1w=2.3530e+05   dvt2w=-2.685e+00 \
     ua=5.6220e-12      ub=9.5730e-19      uc=7.1200e-13 \
u0=4.4180e+02 \
   dsub=5.2500e+00    eta0=1.0000e-07    etab=-3.000e-01 \
nfactor=9.0620e-01 \
     em=4.1000e+07    pclm=2.8550e+00 \
  drout=5.0000e-01 \
     a0=8.2080e-01      a1=0.0000e+00      a2=1.0000e+00 \
   pvag=0.0000e+00    vsat=8.9380e+04     ags=1.8620e-02      b0=3.0590e-09      b1=2.6720e-02 \
  delta=3.7770e-05 pdiblcb=1.0000e-12 \
pdiblc1=5.1750e-04 pdiblc2=3.7770e-07 \
     w0=-4.630e-06 \
    dlc=-5.451e-07 \
    dwc=2.7390e-07     dwb=0.0000e+00     dwg=0.0000e+00 \
     ll=0.0000e+00      lw=0.0000e+00     lwl=0.0000e+00 \
    lln=1.0000e+00     lwn=1.0000e+00      wl=0.0000e+00 \
     ww=0.0000e+00     wwl=0.0000e+00     wln=1.0000e+00 \
    wwn=1.0000e+00 \
     at=3.3000e+04     ute=-1.710e+00 \
    kt1=-4.600e-01     kt2=2.2000e-02    kt1l=0.0000e+00 \
    ua1=0.0000e+00     ub1=0.0000e+00     uc1=0.0000e+00 \
    prt=0.0000e+00 \
   cgso=1.0710e-10    cgdo=1.0000e-15    cgbo=1.1000e-10 \
   cgdl=5.0000e-10    cgsl=4.8800e-10  ckappa=1.9890e+00 \
     cf=0.0000e+00     elm=5.0000e+00 \
  xpart=5.0000e-01     clc=1.0000e-15     cle=6.0000e-01 \
\
   rdsw=0.0000e+00 \
   cdsc=1.9360e-06   cdscb=1.0000e-12   cdscd=1.0740e-08 \
   prwb=0.0000e+00    prwg=0.0000e+00     cit=1.0740e-06 \
tox=1.5400e-08 \
  ngate=0.0000e+00 \
    nlx=2.6040e-07 \
     xl=0.0000e+00      xw=0.0000e+00 \
     af=1.9886e+00      kf=1.6086e-24      ef=1.0000e+00 \
   noia=2.5794e+19    noib=1.0199e+05    noic=-2.372e-12 \
     rd=0.0000e+00      rs=0.0000e+00     rsh=7.5000e+01 \
   minr=1.000e-03 \
    rdc=0.0000e+00     rsc=0.0000e+00 lint=-2.271e-07 \
wint=2.7390e-07   ldif=0.000e+00    hdif=8.0000e-07 \
     xj=9.0000e-07      js=3.5530e-07 \
      n=1.0000e+00 \
  dskip=no          tlev=0           tlevc=0         \
    jsw=1.7560e-12 \
     cj=8.4000e-04    cjsw=2.5000e-10 \
     fc=0.0000e+00    fcsw=0.000e+00 \
     mj=3.4000e-01    mjsw=2.3000e-01 \
     pb=6.9000e-01    pbsw=6.9000e-01     xti=2.0260e+00
ends modn30m
// HV-jfet 1
inline subckt modn30mjfet1 (d b s)
parameters w=1e-6
modn30mjfet1 (d b s) rnjfetinsub
model rnjfetinsub jfet type=n \
beta=4.4210e+00/(1+(2.8000e-03)*(temp-(2.7000e+01)))*(w+(1.6670e-06))/(1+(6.0000e-03)*(temp-27)) \
vto=-5.700e+00*(1+(2.8000e-03)*(temp-(2.7000e+01))) \
lambda=0.0000e+00 \
is=0.0000e+00  pb=5.0000e-01 \
cgs=0.0000e+00 rs=0.0000e+00 \
cgd=0.0000e+00 rd=0.0000e+00
ends modn30mjfet1
// HV-jfet 2
inline subckt  modn30mjfet2 (d b s)
parameters w=1e-6
modn30mjfet2 (d b s) rnjfetinsub
model rnjfetinsub jfet type=n \
beta=4.4900e+00/(1+(2.8000e-03)*(temp-(2.7000e+01)))*(w+(1.6670e-06))/(1+(6.0000e-03)*(temp-27)) \
vto=-7.957e+00*(1+(2.8000e-03)*(temp-(2.7000e+01))) \
lambda=0.0000e+00 \
is=0.0000e+00  pb=5.0000e-01 \
cgs=0.0000e+00 rs=0.0000e+00 \
cgd=0.0000e+00 rd=0.0000e+00
ends modn30mjfet2
//

inline subckt modn30mnwd ( a c )
parameters area=1.0e-12 perimeter=1.0e-6
modn30mnwd ( a c ) diodeinsub area=area perim=perimeter region=off
model diodeinsub diode level=1 dskip=no \
is=1.676e-06          isw=2.158e-11                n=1.000e+00 ns=1.000e+00 \
minr=0.100e+00   imax=(1.000e+00/area) \
cj0=8.798e-05        m=2.737e-01                  vj=5.300e-01 tt=0.000e+00 \
cjsw=6.611e-10       mjsw=2.122e-01             vjsw=5.300e-01 fc=0.000e+00\
af=1.000e+00     kf=0.000e+00            xti=1.366e+00
ends modn30mnwd
// ----------------------------------------------------------------------
// Owner: austriamicrosystems
// HIT-Kit: Digital
// ************************ SIMULATION PARAMETERS ************************
//  ----------------------------------------------------------------------
//  format    : Spectre (Spectre Direct)
//  model     : MOS BSIM3v3
//  process   : c35
//  revision  : ;
//  extracted : B58737.W09PE6; 2008-06; kmo(5966)
//  doc#      : ENG-327 Rev.2.0
//  ----------------------------------------------------------------------
//                         TYPICAL MEAN CONDITION
//  ----------------------------------------------------------------------
//  HV-TRANSISTOR
//  ----------------------------------------------------------------------
inline subckt modn18t ( d g s b )
// Parameters: w l nrd nrs ad as pd ps
parameters w=1.0e-6 l=1.0e-6 nrd=0.0 nrs=0.0 ad=0.0 as=0.0 pd=0.0 ps=0.0 mult=1 gv=(2.8290e-07/l + 8.9230e-01) dcdc=1
+ dvthmat=mv_modn18t*(0.78e-08/sqrt(l*w*mult)) dumat=mu_modn18t*(6.9e-09/sqrt(l*w*mult))
if (modn18t==1){
//
modn18t ( d1 g s1 b ) mosinsub w=w l=l nrd=0 nrs=8.0000e-07/w ad=0 as=as pd=0 ps=ps
rd ( d1 d ) resistor r=(9.9540e-01/(w+(2.4730e-06))) tc1=5.0000e-03
xj1 ( d gj d1 ) modn18tjfet1 w=w
xj2 ( d gj d1 ) modn18tjfet2 w=w
e1 ( d1 gj d1 s ) vcvs gain=gv min=-25 max=25
cgdx ( g d ) capacitor c=(4.4000e-10*w)
v1 ( s1 s ) vsource dc=0 type=dc
i1 ( d b ) bsource i=((5.3850e-10)/(l+(0.0000e+00))+(4.8260e-03))*i("v1:p")*(max((v(d,g)+(2.9600e-02)),1e-15))**(3.8580e+00)*exp((-4.2900e+00)/max((v(d,g)+(2.9600e-02)),1e-10))*(w+0.0000e+00)/w/(1+3.3810e+04*exp(5.3330e-03*i("v1:p")/(w+0.0000e+00)))
xdw ( b d1 ) modn18tnwd area=(1e-06*2.35*(w+1e-06*16)) perimeter=(4e-06*2.35+(w+1e-06*16))
}else
modn18t ( d s ) resistor r=1e30
notvalid paramtest errorif=(modn18t==0) \
message="
***************************************************
*
* nmos18t is not valid in selected process option.
*
***************************************************"
//
model mosinsub bsim3v3 version=3.1 type=n  capmod=2.0000e+00 \
 mobmod=1.0000e+00  nqsmod=0.0000e+00  noimod=3.0000e+00 \
   vbox=1.000e+03      k1=6.0871e-01 \
     k2=-3.258e-03      k3=-2.570e+00     k3b=1.9850e+00 \
    nch=2.2110e+17 vth0=4.6760e-01 \
   voff=-8.829e-02    dvt0=1.8190e-01    dvt1=1.0200e-01 \
   dvt2=-5.409e-02    keta=-3.582e-02 \
 pscbe1=3.5770e+12  pscbe2=5.7730e-12 \
 alpha0=0.0000e+00   beta0=3.0000e+01 \
  dvt0w=7.9230e-01   dvt1w=6.0330e+05   dvt2w=-2.792e+00 \
     ua=2.1750e-10      ub=4.8850e-19      uc=1.2070e-10 \
u0=3.8760e+02 \
   dsub=5.2500e+00    eta0=1.0000e-07    etab=-3.000e-01 \
nfactor=8.6770e-01 \
     em=4.1000e+07    pclm=6.0510e+00 \
  drout=5.0000e-01 \
     a0=7.6440e-01      a1=0.0000e+00      a2=1.0000e+00 \
   pvag=0.0000e+00    vsat=5.5760e+04     ags=2.3440e-01      b0=4.4050e-09      b1=2.6720e-02 \
  delta=2.5490e-05 pdiblcb=1.0000e-12 \
pdiblc1=2.2650e+00 pdiblc2=1.0000e-09 \
     w0=-7.990e-01 \
    dlc=-7.640e-07 \
    dwc=1.6680e-07     dwb=0.0000e+00     dwg=0.0000e+00 \
     ll=0.0000e+00      lw=0.0000e+00     lwl=0.0000e+00 \
    lln=1.0000e+00     lwn=1.0000e+00      wl=0.0000e+00 \
     ww=0.0000e+00     wwl=0.0000e+00     wln=1.0000e+00 \
    wwn=1.0000e+00 \
     at=3.3000e+04     ute=-1.720e+00 \
    kt1=-3.210e-01     kt2=2.2000e-02    kt1l=0.0000e+00 \
    ua1=0.0000e+00     ub1=0.0000e+00     uc1=0.0000e+00 \
    prt=0.0000e+00 \
   cgso=1.1750e-10    cgdo=1.0000e-15    cgbo=1.1000e-10 \
   cgdl=4.4020e-10    cgsl=5.0000e-10  ckappa=6.2280e-01 \
     cf=0.0000e+00     elm=5.0000e+00 \
  xpart=5.0000e-01     clc=1.0000e-15     cle=6.0000e-01 \
\
   rdsw=0.0000e+00 \
   cdsc=5.0330e-20   cdscb=2.9060e-04   cdscd=7.3780e-10 \
   prwb=0.0000e+00    prwg=0.0000e+00     cit=7.3780e-08 \
tox=7.6000e-09 \
  ngate=0.0000e+00 \
    nlx=1.4630e-07 \
     xl=0.0000e+00      xw=0.0000e+00 \
     af=2.0045e+00      kf=8.5977e-25      ef=1.0000e+00 \
   noia=4.8618e+18    noib=2.9560e+04    noic=-2.148e-13 \
     rd=0.0000e+00      rs=0.0000e+00     rsh=7.5000e+01 \
   minr=1.000e-03 \
    rdc=0.0000e+00     rsc=0.0000e+00 lint=-3.414e-07 \
wint=1.6680e-07   ldif=0.000e+00    hdif=8.0000e-07 \
     xj=9.0000e-07      js=3.5530e-07 \
      n=1.0000e+00 \
  dskip=no          tlev=0           tlevc=0         \
    jsw=1.7560e-12 \
     cj=8.4000e-04    cjsw=2.5000e-10 \
     fc=0.0000e+00    fcsw=0.000e+00 \
     mj=3.4000e-01    mjsw=2.3000e-01 \
     pb=6.9000e-01    pbsw=6.9000e-01     xti=2.0260e+00
ends modn18t
// HV-jfet 1
inline subckt modn18tjfet1 (d b s)
parameters w=1e-6
modn18tjfet1 (d b s) rnjfetinsub
model rnjfetinsub jfet type=n \
beta=4.0710e+00/(1+(1.6000e-03)*(temp-(2.7000e+01)))*(w+(2.4730e-06))/(1+(5.0000e-03)*(temp-27)) \
vto=-7.402e+00*(1+(1.6000e-03)*(temp-(2.7000e+01))) \
lambda=0.0000e+00 \
is=0.0000e+00  pb=5.0000e-01 \
cgs=0.0000e+00 rs=0.0000e+00 \
cgd=0.0000e+00 rd=0.0000e+00
ends modn18tjfet1
// HV-jfet 2
inline subckt  modn18tjfet2 (d b s)
parameters w=1e-6
modn18tjfet2 (d b s) rnjfetinsub
model rnjfetinsub jfet type=n \
beta=1.9980e+00/(1+(1.6000e-03)*(temp-(2.7000e+01)))*(w+(2.4730e-06))/(1+(5.0000e-03)*(temp-27)) \
vto=-7.947e+00*(1+(1.6000e-03)*(temp-(2.7000e+01))) \
lambda=0.0000e+00 \
is=0.0000e+00  pb=5.0000e-01 \
cgs=0.0000e+00 rs=0.0000e+00 \
cgd=0.0000e+00 rd=0.0000e+00
ends modn18tjfet2
//

inline subckt modn18tnwd ( a c )
parameters area=1.0e-12 perimeter=1.0e-6
modn18tnwd ( a c ) diodeinsub area=area perim=perimeter region=off
model diodeinsub diode level=1 dskip=no \
is=2.159e-06          isw=3.227e-11                n=1.000e+00 ns=1.000e+00 \
minr=0.100e+00   imax=(1.000e+00/area) \
cj0=8.992e-05        m=2.671e-01                  vj=5.300e-01 tt=0.000e+00 \
cjsw=6.406e-10       mjsw=2.161e-01             vjsw=5.300e-01 fc=0.000e+00\
af=1.000e+00     kf=0.000e+00            xti=4.786e-01
ends modn18tnwd

// ----------------------------------------------------------------------
// Owner: austriamicrosystems
// HIT-Kit: Digital
// ************************ SIMULATION PARAMETERS ************************
//  ----------------------------------------------------------------------
//  format    : Spectre (Spectre Direct)
//  model     : MOS HiSIM_HV
//  process   : c35
//  revision  : REVISION 3.0 Wafer C50118W01 2013/12/12;
//  extracted : MCT;
//  doc#      : Eng-327 REV 5.0
//  ----------------------------------------------------------------------
//                         TYPICAL MEAN CONDITION
//  ----------------------------------------------------------------------
//
// UNSYMMETRIC HV-TRANSISTOR WITH EXTENDED PARASITICS
// PARAMS: NRD NRS AD AS PD PS AW PW (SEE NETLIST FORMAT DOC.)
// NMOS: N-Well Diode
// PMOS: P-Well Diode + PSUB+Diode
//  ----------------------------------------------------------------------
inline subckt modpd30m ( d g s b psub )
// Parameters: w l nrd nrs ad as pd ps
parameters w=1.0e-6 l=1.0e-6 nrd=0.0 nrs=0.0 ad=0.0 as=0.0 pd=0.0 ps=0.0 mult=1 dtemp=0
+ isoVoltage=50
+ dvthmat=(mv_modpd30m)*(1.73e-08/sqrt(l*w*mult)) dumat=(mu_modpd30m)*(6.15e-09/sqrt(l*w*mult))
if (modpd30m==1){
modpd30m ( d g s b ) mosinsub w=w l=l nrd=0 nrs=8.0000e-07/w ad=0 as=as pd=0 ps=ps
xpd ( d b ) modpd30mpd area=w*3.7e-06 perimeter=3.7e-06*2*mult
xnwd ( psub b ) modpd30mnwd area=(w+1e-06*23.6)*(l+1e-06*8.25) perimeter=4*(l+1e-06*8.25)+(w+1e-06*23.6)
}else
modpd30m ( d s ) resistor r=1e30
notvalid paramtest errorif=(modpd30m==0) \
message="
***************************************************
*
* pmosd30m is not valid in selected process option.
*
***************************************************"
//
model mosinsub hisim_hv version=1.230e+00 type=p \
 corsrd=3.0000e+00  coovlp=1.0000e+00 coovlps=1.0000e+00 \
 coisub=0.0000e+00  coiigs=0.0000e+00  cogidl=0.0000e+00 \
 coisti=0.0000e+00  coadov=1.0000e+00   conqs=0.0000e+00 \
   corg=0.0000e+00 corbnet=0.0000e+00 coflick=1.0000e+00 \
cothrml=1.0000e+00   coign=0.0000e+00  coiprv=1 \
  codfm=0.0000e+00 coselfheat=1.0000e+00   cosym=0.0000e+00  \
cosubnode=0.0000e+00  cotemp=0.0000e+00 coldrift=1.0000e+00 \
coqovsm=1.0000e+00  shemax=5.0000e+02  copprv=1.0000e+00
***************************************************************************
*                             Extension to LDMOS                          *
***************************************************************************
+loverld=2.0370e-07   lover=4.9860e-08 ldrift1=1.0000e-06 \
ldrift2=1.0000e-06  novers=1.8290e+17   nover=2.0600e+17
***************************************************************************
*                                   Charges                               *
***************************************************************************
+     xl=0.0000e+00      xw=5.3321e-11     xld=0.0000e+00 \
  xldld=-3.000e-07     xwd=1.6634e-06    xwdc=0.0000e+00   xwdld=0.0000e+00 \
     ll=0.0000e+00     lld=0.0000e+00     lln=0.0000e+00      wl=0.0000e+00 \
    wld=0.0000e+00     wln=0.0000e+00      vfbc=-4.508e-01 \
    vbi=1.1000e+00      tox=1.5000e-08    ddltmax=2.4843e+00 \
ddltslp=0.0000e+00 ddltict=1.0000e+01   kappa=3.9000e+00
***************************************************************************
*                          Threshold Voltage Shift                        *
***************************************************************************
+  parl2=1.0000e-08      sc1=1.2113e+01     sc2=5.0000e-02 \
    sc3=0.0000e+00     sc4=0.0000e+00  pthrou=0.0000e+00 \
     nsubp=1.2013e+17      lp=1.3447e-07     bs1=0.0000e+00 \
    bs2=9.0000e-01    scp1=1.5395e+00    scp2=1.0000e-01 \
   scp3=0.0000e+00   scp21=0.0000e+00   scp22=0.0000e+00 \
  npext=1.0000e+17   lpext=1.0000e-50
***************************************************************************
*                   Depletion Effect of the Gate Poly-Si                  *
***************************************************************************
+   pgd1=0.0000e+00    pgd2=1.0000e+00    pgd3=8.0000e-01 \
   pgd4=0.0000e+00
***************************************************************************
*                       Quantum Mechanical Effects                        *
***************************************************************************
+   qme1=0.0000e+00    qme2=1.0000e+00    qme3=0.0000e+00
***************************************************************************
*                            Mobility Model                               *
***************************************************************************
+muecb0=1.0000e+02     muecb1=7.5427e+01 mueph0=3.0000e-01 \
mueph1=8.3713e+03 muephl=4.3271e-01  mueplp=1.0000e+00 \
 muesr0=2.2790e+00      muesr1=8.6146e+15 muesrl=-1.087e-01 \
 mueslp=1.0000e+00    ndep=1.0000e+00   ndepl=0.0000e+00 \
 ndeplp=1.0000e+00    ninv=5.0000e-01   ninvd=0.0000e+00 \
     bb=1.0000e+00     vmax=6.4148e+06 \
  vover=3.2667e+00 \
 voverp=2.0000e+00
***************************************************************************
*                        Channel Length Modulation                        *
***************************************************************************
+   clm1=5.0000e-01    clm2=4.0000e+00    clm3=1.0000e+00 \
   clm5=1.0000e+00    clm6=0.0000e+00
***************************************************************************
*                          Narrow Channel Effects                         *
***************************************************************************
+    wfc=0.0000e+00   wvth0=-2.159e-01     nsubc=5.5601e+16 \
 nsubcw=0.0000e+00 nsubcwp=1.0000e+00  nsubp0=0.0000e+00 \
 nsubwp=1.0000e+00  muephw=4.5673e+00  muepwp=1.0000e+00 \
 muesrw=7.8626e-02  mueswp=1.0000e+00  vthsti=0.0000e+00 \
  vdsti=0.0000e+00  scsti1=0.0000e+00  scsti2=0.0000e+00 \
   nsti=1.0000e+17    wsti=0.0000e+00   wstil=0.0000e+00 \
 wstilp=1.0000e+00   wstiw=0.0000e+00  wstiwp=1.0000e+00 \
    wl1=0.0000e+00    wl1p=1.0000e+00     wl2=-1.938e-01 \
   wl2p=1.0000e+00  muephs=-5.777e-01  muepsp=1.0000e+00 \
 vovers=-1.000e-01 voversp=0.0000e+00
***************************************************************************
*                          Source/Drain Diffusion                         *
***************************************************************************
+nsubpsti1=0.0000e+00 nsubpsti2=0.0000e+00 nsubpsti3=1.0000e+00 \
muesti1=0.0000e+00 muesti2=0.0000e+00 muesti3=1.0000e+00 \
  saref=1.0000e-06   sbref=1.0000e-06
***************************************************************************
*                         Temperature Dependencies                        *
***************************************************************************
+    eg0=1.1790e+00  bgtmp1=9.0255e-05  bgtmp2=-2.432e-07 \
 muetmp=1.2226e+00    tnom=2.7000e+01    vtmp=3.6866e-01 \
   egig=0.0000e+00 igtemp2=0.0000e+00 igtemp3=0.0000e+00 \
rdtemp1=3.4836e-04 rdtemp2=2.6548e-06 rdvdtemp1=-5.189e-04 \
rdvdtemp2=9.7855e-07
***************************************************************************
*                                Resistances                              *
***************************************************************************
    +rd=7.8094e-03      rs=0.0000e+00     rsh=0.0000e+00 \
   rshg=0.0000e+00    rbpb=5.0000e+01    rbpd=5.0000e+01 \
   rbps=5.0000e+01 \
 rdvg11=6.4018e+00  rdvg12=1.6108e+01     rdvd=4.0529e-02 \
   rdvb=7.4912e-02     rds=-7.748e-01    rdsp=1.0000e+00 \
  rdvdl=0.0000e+00   rdvds=-4.921e-01  rdvdsp=1.0000e+00 \
 rdov11=0.0000e+00  rdov12=1.0000e+00  rdov13=1.0000e+00 \
 rdslp1=0.0000e+00    rd20=0.0000e+00    rd21=1.0000e+00 \
   rd22=-1.312e-01   rd22d=0.0000e+00     rd23=3.7023e-01 \
  rd23l=5.6859e-01  rd23lp=1.0000e+00   rd23s=-1.675e+00 \
 rd23sp=1.0000e+00    rd24=0.0000e+00    rd25=0.0000e+00 \
  gbmin=1.0000e-12
***************************************************************************
*                                Capacitances                             *
***************************************************************************
+    xqy=0.0000e+00    xqy1=0.0000e+00    xqy2=2.0000e+00 \
vfbover=-1.000e+00   qovsm=2.0000e-01   ovslp=2.0000e-08 \
  ovmag=5.0000e+02    cgso=2.0870e-10    cgdo=3.8610e-10 \
   cgbo=1.1000e-10   tpoly=2.0000e-07
***************************************************************************
*                              Leakage Currents                           *
***************************************************************************
+   sub1=5.0000e-02   sub1l=2.5000e-03  sub1lp=1.0000e+00 \
   sub2=3.0048e+01   sub2l=2.0000e-06    svds=8.0000e-01 \
    slg=3.0000e-08    slgl=0.0000e+00   slglp=1.0000e+00 \
   svbs=5.0000e-01   svbsl=0.0000e+00  svbslp=1.0000e+00 \
   svgs=8.0000e-01   svgsl=0.0000e+00  svgslp=1.0000e+00 \
  svgsw=0.0000e+00  svgswp=1.0000e+00   ibpc1=0.0000e+00 \
  ibpc2=0.0000e+00  subld1=0.0000e+00  subld2=0.0000e+00 \
 gleak1=5.0000e+01  gleak2=1.0000e+07  gleak3=6.0000e-02 \
 gleak4=4.0000e+00  gleak5=7.5000e+03  gleak6=2.5000e-01 \
 gleak7=1.0000e-06   glkb1=5.0000e-16   glkb2=1.0000e+00 \
  glkb3=0.0000e+00  glksd1=1.0000e-15  glksd2=1.0000e-02 \
 glksd3=-1.000e-02 glpart1=5.0000e-01     fn1=0.0000e+00 \
    fn2=0.0000e+00     fn3=0.0000e+00    fvbs=0.0000e+00 \
  gidl1=2.0000e+00   gidl2=3.0000e+07   gidl3=9.0000e-01 \
  gidl4=9.0000e-01   gidl5=2.0000e-01
***************************************************************************
*                             S/B and D/B Diodes                          *
***************************************************************************
+    js0=3.0890e-07   js0sw=1.1310e-13      nj=1.0000e+00 \
   njsw=1.0000e+00     xti=3.8400e+00    xti2=3.8400e+00 \
   divx=0.0000e+00    cisb=0.0000e+00     cvb=0.0000e+00 \
  ctemp=0.0000e+00   cisbk=0.0000e+00    cvbk=0.0000e+00 \
     cj=1.3600e-03    cjsw=3.5000e-10   cjswg=3.5000e-10 \
     mj=5.4000e-01    mjsw=4.6000e-01   mjswg=4.6000e-01 \
     pb=1.0200e+00    pbsw=1.0200e+00   pbswg=1.0200e+00 \
 vdiffj=6.0000e-04
***************************************************************************
*                                   Noise                                 *
***************************************************************************
+  nftrp=3.2435e+07   nfalp=1.5485e-18     cit=0.0000e+00 \
  falph=1.0000e+00
***************************************************************************
*                           Non Quasi Static Model                        *
***************************************************************************
+   dly1=1.0000e-10    dly2=7.0000e-01    dly3=8.0000e-07 \
  dlyov=0.0000e+00
***************************************************************************
*                            Self heating Effect                          *
***************************************************************************
+   rth0=5.5684e-01    cth0=1.0000e-07   rth0w=-8.500e+00 \
 rth0wp=1.0000e+00  rth0nf=0.0000e+00
***************************************************************************
*                                   DFM                                   *
***************************************************************************
+ mphdfm=-3.000e-01
***************************************************************************
*                         Additional Node                                 *
***************************************************************************
+ pzadd0=5.0000e-03  vzadd0=1.0000e-02 \
 rdict1=1.0000e+00  rdict2=0.0000e+00  rdvdlp=1.0000e+00 \
 vbsmin=-1.050e+01  rdslp2=1.0000e+00
***************************************************************************
*                         Additional Node                                 *
***************************************************************************
+ rdvsub=3.0000e-01 rdvdsub=1.0000e+00  ddrift=1.0000e-06 \
 vbisub=7.0000e-01 nsubsub=1.0000e+15
ends modpd30m
//

inline subckt modpd30mpd ( a c )
parameters area=1.0e-12 perimeter=1.0e-6
modpd30mpd ( a c ) diodeinsub area=area perim=perimeter region=off
model diodeinsub diode level=1 dskip=no \
  is=6.1140e-07          isw=2.4910e-13 \
   n=1.0400e+00           ns=1.0400e+00 \
minr=0.100e+00          imax=(1.000e+00/area) \
 cj0=1.2340e-03           m=6.2660e-01 \
  vj=1.0200e+00           tt=0.000e+00 \
cjsw=2.8230e-10         mjsw=4.8760e-01 \
vjsw=1.0200e+00           fc=0.000e+00 \
  af=1.000e+00             kf=0.000e+00 \
 xti=2.7630e+00
ends modpd30mpd
//

inline subckt modpd30mnwd ( a c )
parameters area=1.0e-12 perimeter=1.0e-6
modpd30mnwd ( a c ) diodeinsub area=area perim=perimeter region=off
model diodeinsub diode level=1 dskip=no \
  is=7.101e-06          isw=5.386e-12 \
   n=1.000e+00      ns=1.000e+00 \
minr=0.100e+00    imax=(1.000e+00/area) \
 cj0=3.850e-04           m=2.982e-01 \
  vj=5.300e-01          vjsw=5.300e-01 \
  fc=0.000e+00        tt=0.000e+00 \
cjsw=0.000e+00       mjsw=4.401e-01 \
  af=1.000e+00     kf=0.000e+00 \
 xti=-3.138e+00
ends modpd30mnwd

// ----------------------------------------------------------------------
// Owner: austriamicrosystems
// HIT-Kit: Digital
// ************************ SIMULATION PARAMETERS ************************
//  ----------------------------------------------------------------------
//  format    : Spectre (Spectre Direct)
//  model     : MOS HiSIM_HV
//  process   : c35
//  revision  : REVISION 1.0 Wafer C50118W01 2013/12/12;
//  extracted : MCT;
//  doc#      : Eng-327 REV 5.0
//  ----------------------------------------------------------------------
//                         TYPICAL MEAN CONDITION
//  ----------------------------------------------------------------------
//
// UNSYMMETRIC HV-TRANSISTOR WITH EXTENDED PARASITICS
// PARAMS: NRD NRS AD AS PD PS AW PW (SEE NETLIST FORMAT DOC.)
// NMOS: N-Well Diode
// PMOS: P-Well Diode + PSUB+Diode
//  ----------------------------------------------------------------------
inline subckt modp30m ( d g s b psub )
// Parameters: w l nrd nrs ad as pd ps
parameters w=1.0e-6 l=1.0e-6 nrd=0.0 nrs=0.0 ad=0.0 as=0.0 pd=0.0 ps=0.0 mult=1 dtemp=0
+ isoVoltage=50
+ dvthmat=(mv_modp30m)*(1.73e-08/sqrt(l*w*mult)) dumat=(mu_modp30m)*(6.15e-09/sqrt(l*w*mult))
if (modp30m==1){
modp30m ( d g s b ) mosinsub w=w l=l nrd=0 nrs=8.0000e-07/w ad=0 as=as pd=0 ps=ps
xpd ( d b ) modp30mpd area=w*3.7e-06 perimeter=3.7e-06*2*mult
xnwd ( psub b ) modp30mnwd area=(w+1e-06*23.6)*(l+1e-06*8.25) perimeter=4*(l+1e-06*8.25)+(w+1e-06*23.6)
}else
modp30m ( d s ) resistor r=1e30
notvalid paramtest errorif=(modp30m==0) \
message="
***************************************************
*
* pmosd30m is not valid in selected process option.
*
***************************************************"
//
model mosinsub hisim_hv version=1.230e+00 type=p \
 corsrd=3.0000e+00  coovlp=1.0000e+00 coovlps=1.0000e+00 \
 coisub=0.0000e+00  coiigs=0.0000e+00  cogidl=0.0000e+00 \
 coisti=0.0000e+00  coadov=1.0000e+00   conqs=0.0000e+00 \
   corg=0.0000e+00 corbnet=0.0000e+00 coflick=1.0000e+00 \
cothrml=1.0000e+00   coign=0.0000e+00  coiprv=1 \
  codfm=0.0000e+00 coselfheat=1.0000e+00   cosym=0.0000e+00  \
cosubnode=0.0000e+00  cotemp=0.0000e+00 coldrift=1.0000e+00 \
coqovsm=1.0000e+00  shemax=5.0000e+02  copprv=1.0000e+00
***************************************************************************
*                             Extension to LDMOS                          *
***************************************************************************
+loverld=2.0370e-07   lover=4.9860e-08 ldrift1=1.0000e-06 \
ldrift2=1.0000e-06  novers=1.8290e+17   nover=2.0600e+17
***************************************************************************
*                                   Charges                               *
***************************************************************************
+     xl=0.0000e+00      xw=5.3321e-11     xld=0.0000e+00 \
  xldld=-3.000e-07     xwd=1.6634e-06    xwdc=0.0000e+00   xwdld=0.0000e+00 \
     ll=0.0000e+00     lld=0.0000e+00     lln=0.0000e+00      wl=0.0000e+00 \
    wld=0.0000e+00     wln=0.0000e+00      vfbc=-4.508e-01 \
    vbi=1.1000e+00      tox=1.5000e-08    ddltmax=2.4843e+00 \
ddltslp=0.0000e+00 ddltict=1.0000e+01   kappa=3.9000e+00
***************************************************************************
*                          Threshold Voltage Shift                        *
***************************************************************************
+  parl2=1.0000e-08      sc1=1.2113e+01     sc2=5.0000e-02 \
    sc3=0.0000e+00     sc4=0.0000e+00  pthrou=0.0000e+00 \
     nsubp=1.2013e+17      lp=1.3447e-07     bs1=0.0000e+00 \
    bs2=9.0000e-01    scp1=1.5395e+00    scp2=1.0000e-01 \
   scp3=0.0000e+00   scp21=0.0000e+00   scp22=0.0000e+00 \
  npext=1.0000e+17   lpext=1.0000e-50
***************************************************************************
*                   Depletion Effect of the Gate Poly-Si                  *
***************************************************************************
+   pgd1=0.0000e+00    pgd2=1.0000e+00    pgd3=8.0000e-01 \
   pgd4=0.0000e+00
***************************************************************************
*                       Quantum Mechanical Effects                        *
***************************************************************************
+   qme1=0.0000e+00    qme2=1.0000e+00    qme3=0.0000e+00
***************************************************************************
*                            Mobility Model                               *
***************************************************************************
+muecb0=1.0000e+02     muecb1=7.5427e+01 mueph0=3.0000e-01 \
mueph1=8.3713e+03 muephl=4.3271e-01  mueplp=1.0000e+00 \
 muesr0=2.2790e+00      muesr1=8.6146e+15 muesrl=-1.087e-01 \
 mueslp=1.0000e+00    ndep=1.0000e+00   ndepl=0.0000e+00 \
 ndeplp=1.0000e+00    ninv=5.0000e-01   ninvd=0.0000e+00 \
     bb=1.0000e+00     vmax=6.4148e+06 \
  vover=3.2667e+00 \
 voverp=2.0000e+00
***************************************************************************
*                        Channel Length Modulation                        *
***************************************************************************
+   clm1=5.0000e-01    clm2=4.0000e+00    clm3=1.0000e+00 \
   clm5=1.0000e+00    clm6=0.0000e+00
***************************************************************************
*                          Narrow Channel Effects                         *
***************************************************************************
+    wfc=0.0000e+00   wvth0=-2.159e-01     nsubc=5.5601e+16 \
 nsubcw=0.0000e+00 nsubcwp=1.0000e+00  nsubp0=0.0000e+00 \
 nsubwp=1.0000e+00  muephw=4.5673e+00  muepwp=1.0000e+00 \
 muesrw=7.8626e-02  mueswp=1.0000e+00  vthsti=0.0000e+00 \
  vdsti=0.0000e+00  scsti1=0.0000e+00  scsti2=0.0000e+00 \
   nsti=1.0000e+17    wsti=0.0000e+00   wstil=0.0000e+00 \
 wstilp=1.0000e+00   wstiw=0.0000e+00  wstiwp=1.0000e+00 \
    wl1=0.0000e+00    wl1p=1.0000e+00     wl2=-1.938e-01 \
   wl2p=1.0000e+00  muephs=-5.777e-01  muepsp=1.0000e+00 \
 vovers=-1.000e-01 voversp=0.0000e+00
***************************************************************************
*                          Source/Drain Diffusion                         *
***************************************************************************
+nsubpsti1=0.0000e+00 nsubpsti2=0.0000e+00 nsubpsti3=1.0000e+00 \
muesti1=0.0000e+00 muesti2=0.0000e+00 muesti3=1.0000e+00 \
  saref=1.0000e-06   sbref=1.0000e-06
***************************************************************************
*                         Temperature Dependencies                        *
***************************************************************************
+    eg0=1.1790e+00  bgtmp1=9.0255e-05  bgtmp2=-2.432e-07 \
 muetmp=1.2226e+00    tnom=2.7000e+01    vtmp=3.6866e-01 \
   egig=0.0000e+00 igtemp2=0.0000e+00 igtemp3=0.0000e+00 \
rdtemp1=3.4836e-04 rdtemp2=2.6548e-06 rdvdtemp1=-5.189e-04 \
rdvdtemp2=9.7855e-07
***************************************************************************
*                                Resistances                              *
***************************************************************************
    +rd=7.8094e-03      rs=0.0000e+00     rsh=0.0000e+00 \
   rshg=0.0000e+00    rbpb=5.0000e+01    rbpd=5.0000e+01 \
   rbps=5.0000e+01 \
 rdvg11=6.4018e+00  rdvg12=1.6108e+01     rdvd=4.0529e-02 \
   rdvb=7.4912e-02     rds=-7.748e-01    rdsp=1.0000e+00 \
  rdvdl=0.0000e+00   rdvds=-4.921e-01  rdvdsp=1.0000e+00 \
 rdov11=0.0000e+00  rdov12=1.0000e+00  rdov13=1.0000e+00 \
 rdslp1=0.0000e+00    rd20=0.0000e+00    rd21=1.0000e+00 \
   rd22=-1.312e-01   rd22d=0.0000e+00     rd23=3.7023e-01 \
  rd23l=5.6859e-01  rd23lp=1.0000e+00   rd23s=-1.675e+00 \
 rd23sp=1.0000e+00    rd24=0.0000e+00    rd25=0.0000e+00 \
  gbmin=1.0000e-12
***************************************************************************
*                                Capacitances                             *
***************************************************************************
+    xqy=0.0000e+00    xqy1=0.0000e+00    xqy2=2.0000e+00 \
vfbover=-1.000e+00   qovsm=2.0000e-01   ovslp=2.0000e-08 \
  ovmag=5.0000e+02    cgso=2.0870e-10    cgdo=3.8610e-10 \
   cgbo=1.1000e-10   tpoly=2.0000e-07
***************************************************************************
*                              Leakage Currents                           *
***************************************************************************
+   sub1=5.0000e-02   sub1l=2.5000e-03  sub1lp=1.0000e+00 \
   sub2=3.0048e+01   sub2l=2.0000e-06    svds=8.0000e-01 \
    slg=3.0000e-08    slgl=0.0000e+00   slglp=1.0000e+00 \
   svbs=5.0000e-01   svbsl=0.0000e+00  svbslp=1.0000e+00 \
   svgs=8.0000e-01   svgsl=0.0000e+00  svgslp=1.0000e+00 \
  svgsw=0.0000e+00  svgswp=1.0000e+00   ibpc1=0.0000e+00 \
  ibpc2=0.0000e+00  subld1=0.0000e+00  subld2=0.0000e+00 \
 gleak1=5.0000e+01  gleak2=1.0000e+07  gleak3=6.0000e-02 \
 gleak4=4.0000e+00  gleak5=7.5000e+03  gleak6=2.5000e-01 \
 gleak7=1.0000e-06   glkb1=5.0000e-16   glkb2=1.0000e+00 \
  glkb3=0.0000e+00  glksd1=1.0000e-15  glksd2=1.0000e-02 \
 glksd3=-1.000e-02 glpart1=5.0000e-01     fn1=0.0000e+00 \
    fn2=0.0000e+00     fn3=0.0000e+00    fvbs=0.0000e+00 \
  gidl1=2.0000e+00   gidl2=3.0000e+07   gidl3=9.0000e-01 \
  gidl4=9.0000e-01   gidl5=2.0000e-01
***************************************************************************
*                             S/B and D/B Diodes                          *
***************************************************************************
+    js0=3.0890e-07   js0sw=1.1310e-13      nj=1.0000e+00 \
   njsw=1.0000e+00     xti=3.8400e+00    xti2=3.8400e+00 \
   divx=0.0000e+00    cisb=0.0000e+00     cvb=0.0000e+00 \
  ctemp=0.0000e+00   cisbk=0.0000e+00    cvbk=0.0000e+00 \
     cj=1.3600e-03    cjsw=3.5000e-10   cjswg=3.5000e-10 \
     mj=5.4000e-01    mjsw=4.6000e-01   mjswg=4.6000e-01 \
     pb=1.0200e+00    pbsw=1.0200e+00   pbswg=1.0200e+00 \
 vdiffj=6.0000e-04
***************************************************************************
*                                   Noise                                 *
***************************************************************************
+  nftrp=3.2435e+07   nfalp=1.5485e-18     cit=0.0000e+00 \
  falph=1.0000e+00
***************************************************************************
*                           Non Quasi Static Model                        *
***************************************************************************
+   dly1=1.0000e-10    dly2=7.0000e-01    dly3=8.0000e-07 \
  dlyov=0.0000e+00
***************************************************************************
*                            Self heating Effect                          *
***************************************************************************
+   rth0=5.5684e-01    cth0=1.0000e-07   rth0w=-8.500e+00 \
 rth0wp=1.0000e+00  rth0nf=0.0000e+00
***************************************************************************
*                                   DFM                                   *
***************************************************************************
+ mphdfm=-3.000e-01
***************************************************************************
*                         Additional Node                                 *
***************************************************************************
+ pzadd0=5.0000e-03  vzadd0=1.0000e-02 \
 rdict1=1.0000e+00  rdict2=0.0000e+00  rdvdlp=1.0000e+00 \
 vbsmin=-1.050e+01  rdslp2=1.0000e+00
***************************************************************************
*                         Additional Node                                 *
***************************************************************************
+ rdvsub=3.0000e-01 rdvdsub=1.0000e+00  ddrift=1.0000e-06 \
 vbisub=7.0000e-01 nsubsub=1.0000e+15
ends modp30m
//

inline subckt modp30mpd ( a c )
parameters area=1.0e-12 perimeter=1.0e-6
modp30mpd ( a c ) diodeinsub area=area perim=perimeter region=off
model diodeinsub diode level=1 dskip=no \
  is=6.1140e-07          isw=2.4910e-13 \
   n=1.0400e+00           ns=1.0400e+00 \
minr=0.100e+00          imax=(1.000e+00/area) \
 cj0=1.2340e-03           m=6.2660e-01 \
  vj=1.0200e+00           tt=0.000e+00 \
cjsw=2.8230e-10         mjsw=4.8760e-01 \
vjsw=1.0200e+00           fc=0.000e+00 \
  af=1.000e+00             kf=0.000e+00 \
 xti=2.7630e+00
ends modp30mpd
//

inline subckt modp30mnwd ( a c )
parameters area=1.0e-12 perimeter=1.0e-6
modp30mnwd ( a c ) diodeinsub area=area perim=perimeter region=off
model diodeinsub diode level=1 dskip=no \
  is=7.101e-06          isw=5.386e-12 \
   n=1.000e+00      ns=1.000e+00 \
minr=0.100e+00    imax=(1.000e+00/area) \
 cj0=3.850e-04           m=2.982e-01 \
  vj=5.300e-01          vjsw=5.300e-01 \
  fc=0.000e+00        tt=0.000e+00 \
cjsw=0.000e+00       mjsw=4.401e-01 \
  af=1.000e+00     kf=0.000e+00 \
 xti=-3.138e+00
ends modp30mnwd

// ----------------------------------------------------------------------
// Owner: austriamicrosystems
// HIT-Kit: Digital
// ************************ SIMULATION PARAMETERS ************************
//  ----------------------------------------------------------------------
//  format    : Spectre (Spectre Direct)
//  model     : MOS BSIM3v3
//  process   : C35
//  revision  : 1.0;
//  extracted : C18069; 28.08.2011; bse (5866)
//  doc#      : Eng-?? REV_0
//  ----------------------------------------------------------------------
//                          TYPICAL MEAN CONDITION
//
//  ----------------------------------------------------------------------
//
inline subckt nmosw_2n ( d g s b )
parameters w=1.0e-6 l=1.0e-6 nrd=0.0 nrs=0.0 ad=0.0 as=0.0 pd=0.0 ps=0.0 ng=1
+ ws= w
+ ls= l
+ shk=1
//
if (modn==1)
nmosw_2n ( d g s b ) mosinsub w=ws l=ls nrd=8.0000e-07/ws nrs=8.0000e-07/ws ad=ad as=as pd=pd ps=ps m=ng
else
nmosw_2n ( d s ) resistor r=1e30
notvalid paramtest errorif=(modn==0) \
message="
***************************************************
*
* nmos is not valid in selected process option.
*
***************************************************"
model mosinsub bsim3v3 version=3.2400e+00  type=n  capmod=3.0000e+00 \
 mobmod=1.0000e+00  nqsmod=0.0000e+00  noimod=3.0000e+00 \
   vbox=1.000e+03      k1=5.9200e-01 \
     k2=0.0000e+00      k3=3.0270e-02     k3b=-1.089e-02 \
    nch=2.1870e+17 vth0=4.5000e-01 \
   voff=-7.600e-02    dvt0=2.1160e+01    dvt1=1.0640e+00 \
   dvt2=3.0590e-02    keta=-1.200e-02 \
 pscbe1=1.0000e+30  pscbe2=1.0000e-06 \
 alpha0=1.9040e-06  alpha1=2.5000e+00   beta0=2.0000e+01 \
  dvt0w=2.0000e+00   dvt1w=1.6970e+06   dvt2w=-1.556e-02 \
     ua=-3.981e-10      ub=2.6890e-18      uc=6.9180e-11 \
u0=4.2200e+02 \
   dsub=5.0000e-01    eta0=1.4790e-02    etab=-5.280e-02 \
nfactor=2.6780e-01 \
     em=4.1000e+07    pclm=9.6570e-01 \
  drout=5.0000e-01 \
     a0=2.0840e+00      a1=0.0000e+00      a2=1.0000e+00 \
   pvag=1.3460e-01    vsat=1.0200e+05     ags=3.6080e-01      b0=5.0200e-08      b1=1.0060e-07 \
  delta=2.3500e-03 pdiblcb=3.2150e-01 \
pdiblc1=1.0800e-01 pdiblc2=1.6220e-03 \
     w0=-3.185e-07 \
    dlc=-1.588e-08 \
dwc=-3.263e-01*l+1.5050e-07    dwb=0.0000e+00     dwg=-9.302e-09 \
     ll=1.0680e-13      lw=0.0000e+00     lwl=0.0000e+00 \
    lln=1.0000e+00     lwn=1.0000e+00      wl=2.8610e-13 \
     ww=-1.130e-14     wwl=-9.411e-21     wln=1.0000e+00 \
     wr=1.0000e+00     wwn=1.0000e+00 \
     at=2.5000e+04     ute=-1.700e+00 \
    kt1=-3.100e-01     kt2=-1.720e-02    kt1l=0.0000e+00 \
    ua1=0.0000e+00     ub1=0.0000e+00     uc1=0.0000e+00 \
    prt=3.0000e+01 \
   cgso=1.0850e-12    cgdo=1.0850e-12    cgbo=1.7000e-08 \
   cgdl=2.8530e-10    cgsl=2.8530e-10  ckappa=2.6020e+00 \
     cf=0.0000e+00     elm=5.0000e+00 \
  xpart=1.0000e+00     clc=1.0000e-15     cle=6.0000e-01 \
\
   rdsw=1.1390e+03 \
   cdsc=0.0000e+00   cdscb=1.5000e-09   cdscd=0.0000e+00 \
   prwb=-5.000e-02    prwg=1.3340e-02     cit=8.0260e-04 \
tox=7.6700e-09 \
  ngate=1.0000e+00 \
    nlx=1.7000e-07 \
     xl=0.0000e+00      xw=0.0000e+00 \
     af=1.5070e+00      kf=2.1700e-26      ef=1.0000e+00 \
   noia=1.1210e+19    noib=5.3360e+04    noic=-5.892e-13 \
     rd=0.0000e+00      rs=0.0000e+00     rsh=7.5000e+01 \
   minr=1.000e-03 \
    rdc=0.0000e+00     rsc=0.0000e+00 lint=-3.098e-07 \
wint=-8.969e-07   ldif=0.000e+00    hdif=8.0000e-07 \
     xj=3.0000e-07      js=5.1000e-07 \
      n=1.0000e+00 \
  dskip=no          tlev=0           tlevc=0         \
    jsw=6.0000e-13 \
     cj=8.3000e-04    cjsw=2.5000e-10 \
     fc=0.0000e+00    fcsw=0.000e+00 \
     mj=3.4000e-01    mjsw=2.3000e-01 \
     pb=6.9000e-01    pbsw=6.9000e-01     xti=2.0300e+00
ends nmosw_2n

// ----------------------------------------------------------------------

// ----------------------------------------------------------------------
// Owner: austriamicrosystems
// HIT-Kit: Digital
// ************************ SIMULATION PARAMETERS ************************
//  ----------------------------------------------------------------------
//  format    : Spectre (Spectre Direct)
//  model     : MOS BSIM3v3
//  process   : C35
//  revision  : 1.0;
//  extracted : C18069; 28.08.2011; bse (5866)
//  doc#      : Eng-?? REV_0
//  ----------------------------------------------------------------------
//                          TYPICAL MEAN CONDITION
//
//  ----------------------------------------------------------------------
//
inline subckt nmosw_3n ( d g s b )
parameters w=1.0e-6 l=1.0e-6 nrd=0.0 nrs=0.0 ad=0.0 as=0.0 pd=0.0 ps=0.0 ng=1
+ ws= w
+ ls= l
+ shk=1
//
if (modn==1)
nmosw_3n ( d g s b ) mosinsub w=ws l=ls nrd=8.0000e-07/ws nrs=8.0000e-07/ws ad=ad as=as pd=pd ps=ps m=ng
else
nmosw_3n ( d s ) resistor r=1e30
notvalid paramtest errorif=(modn==0) \
message="
***************************************************
*
* nmos is not valid in selected process option.
*
***************************************************"
model mosinsub bsim3v3 version=3.2400e+00  type=n  capmod=3.0000e+00 \
 mobmod=1.0000e+00  nqsmod=0.0000e+00  noimod=3.0000e+00 \
   vbox=1.000e+03      k1=5.9200e-01 \
     k2=0.0000e+00      k3=3.0270e-02     k3b=-1.089e-02 \
    nch=2.1870e+17 vth0=4.5000e-01 \
   voff=-7.600e-02    dvt0=2.1160e+01    dvt1=1.0640e+00 \
   dvt2=3.0590e-02    keta=-1.200e-02 \
 pscbe1=1.0000e+30  pscbe2=1.0000e-06 \
 alpha0=1.9040e-06  alpha1=2.5000e+00   beta0=2.0000e+01 \
  dvt0w=2.0000e+00   dvt1w=1.6970e+06   dvt2w=-1.556e-02 \
     ua=-3.981e-10      ub=2.6890e-18      uc=6.9180e-11 \
u0=4.2200e+02 \
   dsub=5.0000e-01    eta0=1.4790e-02    etab=-5.280e-02 \
nfactor=2.6780e-01 \
     em=4.1000e+07    pclm=9.6570e-01 \
  drout=5.0000e-01 \
     a0=2.0840e+00      a1=0.0000e+00      a2=1.0000e+00 \
   pvag=1.3460e-01    vsat=1.0200e+05     ags=3.6080e-01      b0=5.0200e-08      b1=1.0060e-07 \
  delta=2.3500e-03 pdiblcb=3.2150e-01 \
pdiblc1=2.3600e-01 pdiblc2=2.4880e-03 \
     w0=-3.185e-07 \
    dlc=-1.588e-08 \
dwc=-3.263e-01*l+1.5050e-07    dwb=0.0000e+00     dwg=-9.302e-09 \
     ll=1.0680e-13      lw=0.0000e+00     lwl=0.0000e+00 \
    lln=1.0000e+00     lwn=1.0000e+00      wl=2.8610e-13 \
     ww=-1.130e-14     wwl=-9.411e-21     wln=1.0000e+00 \
     wr=1.0000e+00     wwn=1.0000e+00 \
     at=2.5000e+04     ute=-1.700e+00 \
    kt1=-3.100e-01     kt2=-1.720e-02    kt1l=0.0000e+00 \
    ua1=0.0000e+00     ub1=0.0000e+00     uc1=0.0000e+00 \
    prt=3.0000e+01 \
   cgso=1.0850e-12    cgdo=1.0850e-12    cgbo=1.7000e-08 \
   cgdl=2.8530e-10    cgsl=2.8530e-10  ckappa=2.6020e+00 \
     cf=0.0000e+00     elm=5.0000e+00 \
  xpart=1.0000e+00     clc=1.0000e-15     cle=6.0000e-01 \
\
   rdsw=1.1390e+03 \
   cdsc=0.0000e+00   cdscb=1.5000e-09   cdscd=0.0000e+00 \
   prwb=-1.471e-01    prwg=1.3340e-02     cit=8.0260e-04 \
tox=7.6700e-09 \
  ngate=1.0000e+00 \
    nlx=1.7000e-07 \
     xl=0.0000e+00      xw=0.0000e+00 \
     af=1.5070e+00      kf=2.1700e-26      ef=1.0000e+00 \
   noia=1.1210e+19    noib=5.3360e+04    noic=-5.892e-13 \
     rd=0.0000e+00      rs=0.0000e+00     rsh=7.5000e+01 \
   minr=1.000e-03 \
    rdc=0.0000e+00     rsc=0.0000e+00 lint=-3.098e-07 \
wint=-8.216e-07   ldif=0.000e+00    hdif=8.0000e-07 \
     xj=3.0000e-07      js=5.1000e-07 \
      n=1.0000e+00 \
  dskip=no          tlev=0           tlevc=0         \
    jsw=6.0000e-13 \
     cj=8.3000e-04    cjsw=2.5000e-10 \
     fc=0.0000e+00    fcsw=0.000e+00 \
     mj=3.4000e-01    mjsw=2.3000e-01 \
     pb=6.9000e-01    pbsw=6.9000e-01     xti=2.0300e+00
ends nmosw_3n

// ----------------------------------------------------------------------

// ----------------------------------------------------------------------
// Owner: austriamicrosystems
// HIT-Kit: Digital
// ************************ SIMULATION PARAMETERS ************************
//  ----------------------------------------------------------------------
//  format    : Spectre (Spectre Direct)
//  model     : MOS BSIM3v3
//  process   : C35
//  revision  : 1.0;
//  extracted : C18069; 28.08.2011; bse (5866)
//  doc#      : Eng-?? REV_0
//  ----------------------------------------------------------------------
//                          TYPICAL MEAN CONDITION
//
//  ----------------------------------------------------------------------
//
inline subckt nmosw_4n ( d g s b )
parameters w=1.0e-6 l=1.0e-6 nrd=0.0 nrs=0.0 ad=0.0 as=0.0 pd=0.0 ps=0.0 ng=1
+ ws= w
+ ls= l
+ shk=1
//
if (modn==1)
nmosw_4n ( d g s b ) mosinsub w=ws l=ls nrd=8.0000e-07/ws nrs=8.0000e-07/ws ad=ad as=as pd=pd ps=ps m=ng
else
nmosw_4n ( d s ) resistor r=1e30
notvalid paramtest errorif=(modn==0) \
message="
***************************************************
*
* nmos is not valid in selected process option.
*
***************************************************"
model mosinsub bsim3v3 version=3.2400e+00  type=n  capmod=3.0000e+00 \
 mobmod=1.0000e+00  nqsmod=0.0000e+00  noimod=3.0000e+00 \
   vbox=1.000e+03      k1=5.9200e-01 \
     k2=0.0000e+00      k3=3.0270e-02     k3b=-1.089e-02 \
    nch=2.1870e+17 vth0=4.5000e-01 \
   voff=-7.600e-02    dvt0=2.1160e+01    dvt1=1.0640e+00 \
   dvt2=3.0590e-02    keta=-1.200e-02 \
 pscbe1=1.0000e+30  pscbe2=1.0000e-06 \
 alpha0=1.9040e-06  alpha1=2.5000e+00   beta0=2.0000e+01 \
  dvt0w=2.0000e+00   dvt1w=1.6970e+06   dvt2w=-1.556e-02 \
     ua=-3.981e-10      ub=2.5120e-18      uc=6.9180e-11 \
u0=4.2200e+02 \
   dsub=5.0000e-01    eta0=1.4790e-02    etab=-5.280e-02 \
nfactor=2.6780e-01 \
     em=4.1000e+07    pclm=9.6570e-01 \
  drout=5.0000e-01 \
     a0=2.0840e+00      a1=0.0000e+00      a2=1.0000e+00 \
   pvag=1.3460e-01    vsat=1.0200e+05     ags=3.1620e-01      b0=5.0200e-08      b1=1.0060e-07 \
  delta=2.3500e-03 pdiblcb=3.2150e-01 \
pdiblc1=8.3400e-01 pdiblc2=2.4880e-03 \
     w0=-3.185e-07 \
    dlc=-1.588e-08 \
dwc=-3.263e-01*l+1.5050e-07    dwb=0.0000e+00     dwg=-9.302e-09 \
     ll=0.0000e+00      lw=0.0000e+00     lwl=0.0000e+00 \
    lln=1.0000e+00     lwn=1.0000e+00      wl=-1.924e-13 \
     ww=0.0000e+00     wwl=0.0000e+00     wln=1.0000e+00 \
     wr=1.0000e+00     wwn=1.0000e+00 \
     at=2.5000e+04     ute=-1.700e+00 \
    kt1=-3.100e-01     kt2=-1.720e-02    kt1l=0.0000e+00 \
    ua1=0.0000e+00     ub1=0.0000e+00     uc1=0.0000e+00 \
    prt=-2.456e+02 \
   cgso=1.0850e-12    cgdo=1.0850e-12    cgbo=1.7000e-08 \
   cgdl=2.8530e-10    cgsl=2.8530e-10  ckappa=2.6020e+00 \
     cf=0.0000e+00     elm=5.0000e+00 \
  xpart=1.0000e+00     clc=1.0000e-15     cle=6.0000e-01 \
\
   rdsw=1.1410e+03 \
   cdsc=0.0000e+00   cdscb=1.5000e-09   cdscd=0.0000e+00 \
   prwb=-7.244e-02    prwg=1.1740e-01     cit=8.0260e-04 \
tox=7.6700e-09 \
  ngate=1.0000e+00 \
    nlx=1.7000e-07 \
     xl=0.0000e+00      xw=0.0000e+00 \
     af=1.5070e+00      kf=2.1700e-26      ef=1.0000e+00 \
   noia=1.1210e+19    noib=5.3360e+04    noic=-5.892e-13 \
     rd=0.0000e+00      rs=0.0000e+00     rsh=7.5000e+01 \
   minr=1.000e-03 \
    rdc=0.0000e+00     rsc=0.0000e+00 lint=-1.868e-07 \
wint=-3.544e-07   ldif=0.000e+00    hdif=8.0000e-07 \
     xj=3.0000e-07      js=5.1000e-07 \
      n=1.0000e+00 \
  dskip=no          tlev=0           tlevc=0         \
    jsw=6.0000e-13 \
     cj=8.3000e-04    cjsw=2.5000e-10 \
     fc=0.0000e+00    fcsw=0.000e+00 \
     mj=3.4000e-01    mjsw=2.3000e-01 \
     pb=6.9000e-01    pbsw=6.9000e-01     xti=2.0300e+00
ends nmosw_4n

// ----------------------------------------------------------------------

// ----------------------------------------------------------------------
// Owner: austriamicrosystems
// HIT-Kit: Digital
// ************************ SIMULATION PARAMETERS ************************
//  ----------------------------------------------------------------------
//  format    : Spectre (Spectre Direct)
//  model     : MOS BSIM3v3
//  process   : C35
//  revision  : 1.0;
//  extracted : C18069; 28.08.2011; bse (5866)
//  doc#      : Eng-?? REV_0
//  ----------------------------------------------------------------------
//                          TYPICAL MEAN CONDITION
//
//  ----------------------------------------------------------------------
//
inline subckt nmosmw_2n ( d g s b )
parameters w=1.0e-6 l=1.0e-6 nrd=0.0 nrs=0.0 ad=0.0 as=0.0 pd=0.0 ps=0.0 ng=1
+ ws= w
+ ls= l
+ shk=1
//
if (modnm==1)
nmosmw_2n ( d g s b ) mosinsub w=ws l=ls nrd=6.0000e-07/ws nrs=6.0000e-07/ws ad=ad as=as pd=pd ps=ps m=ng
else
nmosmw_2n ( d s ) resistor r=1e30
notvalid paramtest errorif=(modnm==0) \
message="
***************************************************
*
* nmosm is not valid in selected process option.
*
***************************************************"
model mosinsub bsim3v3 version=3.2400e+00  type=n  capmod=3.0000e+00 \
 mobmod=1.0000e+00  nqsmod=0.0000e+00  noimod=3.0000e+00 \
   vbox=1.000e+03      k1=1.0000e+00 \
     k2=0.0000e+00      k3=-2.500e+00     k3b=-5.640e-02 \
    nch=1.4460e+17 vth0=7.1900e-01 \
   voff=-9.684e-02    dvt0=2.0510e+01    dvt1=1.0610e+00 \
   dvt2=2.5970e-02    keta=3.2000e-02 \
 pscbe1=1.0000e+30  pscbe2=1.0000e-06 \
 alpha0=5.5350e-08  alpha1=1.3930e-01   beta0=1.9570e+01 \
  dvt0w=1.0800e+01   dvt1w=3.0990e+06   dvt2w=1.4520e-01 \
     ua=1.4200e-12      ub=1.7380e-18      uc=5.7540e-11 \
u0=5.0600e+02 \
   dsub=5.0000e-01    eta0=4.0860e-02    etab=-1.000e-03 \
nfactor=8.6050e-01 \
     em=4.1000e+07    pclm=9.0000e-01 \
  drout=5.0000e-01 \
     a0=1.0000e+00      a1=0.0000e+00      a2=1.0000e+00 \
   pvag=6.0000e-02    vsat=5.3380e+04     ags=1.9140e-01      b0=2.0000e-08      b1=1.0000e-08 \
  delta=1.0000e-02 pdiblcb=9.7980e-01 \
pdiblc1=2.4800e-01 pdiblc2=1.2400e-03 \
     w0=3.3160e-08 \
    dlc=1.3960e-09 \
dwc=-2.884e-01*l+1.4740e-07    dwb=8.6800e-09     dwg=-3.770e-09 \
     ll=7.4510e-14      lw=0.0000e+00     lwl=0.0000e+00 \
    lln=1.0000e+00     lwn=1.0000e+00      wl=-3.626e-13 \
     ww=-1.514e-14     wwl=-1.321e-20     wln=1.0000e+00 \
     wr=1.0000e+00     wwn=1.0000e+00 \
     at=3.3000e+04     ute=-1.720e+00 \
    kt1=-4.180e-01     kt2=-4.560e-02    kt1l=0.0000e+00 \
    ua1=0.0000e+00     ub1=0.0000e+00     uc1=0.0000e+00 \
    prt=0.0000e+00 \
   cgso=1.0050e-10    cgdo=1.0050e-10    cgbo=1.6000e-08 \
   cgdl=1.0000e-10    cgsl=1.0000e-10  ckappa=2.9570e+00 \
     cf=0.0000e+00     elm=5.0000e+00 \
  xpart=1.0000e+00     clc=1.0000e-15     cle=6.0000e-01 \
\
   rdsw=3.0420e+03 \
   cdsc=0.0000e+00   cdscb=2.0000e-03   cdscd=0.0000e+00 \
   prwb=5.0000e-02    prwg=4.3480e-03     cit=0.0000e+00 \
tox=1.5000e-08 \
  ngate=1.0000e+00 \
    nlx=1.5690e-07 \
     xl=0.0000e+00      xw=0.0000e+00 \
     af=1.6290e+00      kf=9.1800e-26      ef=1.0000e+00 \
   noia=2.2450e+19    noib=1.1680e+05    noic=-1.680e-12 \
     rd=0.0000e+00      rs=0.0000e+00     rsh=7.9000e+01 \
   minr=1.000e-03 \
    rdc=0.0000e+00     rsc=0.0000e+00 lint=-3.093e-07 \
wint=-8.560e-07   ldif=0.000e+00    hdif=6.0000e-07 \
     xj=3.0000e-07      js=5.1000e-07 \
      n=1.0000e+00 \
  dskip=no          tlev=0           tlevc=0         \
    jsw=6.0000e-13 \
     cj=8.3000e-04    cjsw=2.5000e-10 \
     fc=0.0000e+00    fcsw=0.000e+00 \
     mj=3.4000e-01    mjsw=2.3000e-01 \
     pb=6.9000e-01    pbsw=6.9000e-01     xti=2.0300e+00
ends nmosmw_2n

// ----------------------------------------------------------------------

// ----------------------------------------------------------------------
// Owner: austriamicrosystems
// HIT-Kit: Digital
// ************************ SIMULATION PARAMETERS ************************
//  ----------------------------------------------------------------------
//  format    : Spectre (Spectre Direct)
//  model     : MOS BSIM3v3
//  process   : C35
//  revision  : 1.0;
//  extracted : C18069; 28.08.2011; bse (5866)
//  doc#      : Eng-?? REV_0
//  ----------------------------------------------------------------------
//                          TYPICAL MEAN CONDITION
//
//  ----------------------------------------------------------------------
//
inline subckt nmosmw_3n ( d g s b )
parameters w=1.0e-6 l=1.0e-6 nrd=0.0 nrs=0.0 ad=0.0 as=0.0 pd=0.0 ps=0.0 ng=1
+ ws= w
+ ls= l
+ shk=1
//
if (modnm==1)
nmosmw_3n ( d g s b ) mosinsub w=ws l=ls nrd=6.0000e-07/ws nrs=6.0000e-07/ws ad=ad as=as pd=pd ps=ps m=ng
else
nmosmw_3n ( d s ) resistor r=1e30
notvalid paramtest errorif=(modnm==0) \
message="
***************************************************
*
* nmosm is not valid in selected process option.
*
***************************************************"
model mosinsub bsim3v3 version=3.2400e+00  type=n  capmod=3.0000e+00 \
 mobmod=1.0000e+00  nqsmod=0.0000e+00  noimod=3.0000e+00 \
   vbox=1.000e+03      k1=1.0000e+00 \
     k2=0.0000e+00      k3=-2.500e+00     k3b=-5.640e-02 \
    nch=1.4460e+17 vth0=7.1900e-01 \
   voff=-9.684e-02    dvt0=2.0510e+01    dvt1=1.0610e+00 \
   dvt2=2.5970e-02    keta=3.2000e-02 \
 pscbe1=1.0000e+30  pscbe2=1.0000e-06 \
 alpha0=5.5350e-08  alpha1=1.3930e-01   beta0=1.9570e+01 \
  dvt0w=1.0800e+01   dvt1w=3.0990e+06   dvt2w=1.4520e-01 \
     ua=1.4200e-12      ub=1.7380e-18      uc=5.7540e-11 \
u0=5.0600e+02 \
   dsub=5.0000e-01    eta0=4.0860e-02    etab=-1.000e-03 \
nfactor=8.6050e-01 \
     em=4.1000e+07    pclm=9.0000e-01 \
  drout=5.0000e-01 \
     a0=1.0000e+00      a1=0.0000e+00      a2=1.0000e+00 \
   pvag=6.0000e-02    vsat=6.1710e+04     ags=1.9140e-01      b0=2.0000e-08      b1=1.0000e-08 \
  delta=1.0000e-02 pdiblcb=9.7980e-01 \
pdiblc1=1.4000e-01 pdiblc2=1.3490e-03 \
     w0=3.3160e-08 \
    dlc=1.3960e-09 \
dwc=-2.884e-01*l+1.4740e-07    dwb=8.6800e-09     dwg=-3.770e-09 \
     ll=7.4510e-14      lw=0.0000e+00     lwl=0.0000e+00 \
    lln=1.0000e+00     lwn=1.0000e+00      wl=-1.968e-13 \
     ww=-1.514e-14     wwl=-1.321e-20     wln=1.0000e+00 \
     wr=1.0000e+00     wwn=1.0000e+00 \
     at=3.3000e+04     ute=-1.720e+00 \
    kt1=-4.180e-01     kt2=-4.560e-02    kt1l=0.0000e+00 \
    ua1=0.0000e+00     ub1=0.0000e+00     uc1=0.0000e+00 \
    prt=0.0000e+00 \
   cgso=1.0050e-10    cgdo=1.0050e-10    cgbo=1.6000e-08 \
   cgdl=1.0050e-10    cgsl=1.0050e-10  ckappa=2.9570e+00 \
     cf=0.0000e+00     elm=5.0000e+00 \
  xpart=1.0000e+00     clc=1.0000e-15     cle=6.0000e-01 \
\
   rdsw=2.5390e+03 \
   cdsc=0.0000e+00   cdscb=2.0000e-03   cdscd=0.0000e+00 \
   prwb=5.0000e-02    prwg=4.3480e-03     cit=0.0000e+00 \
tox=1.5000e-08 \
  ngate=1.0000e+00 \
    nlx=1.5690e-07 \
     xl=0.0000e+00      xw=0.0000e+00 \
     af=1.6290e+00      kf=9.1800e-26      ef=1.0000e+00 \
   noia=2.2450e+19    noib=1.1680e+05    noic=-1.680e-12 \
     rd=0.0000e+00      rs=0.0000e+00     rsh=7.9000e+01 \
   minr=1.000e-03 \
    rdc=0.0000e+00     rsc=0.0000e+00 lint=-2.609e-07 \
wint=-6.127e-07   ldif=0.000e+00    hdif=6.0000e-07 \
     xj=3.0000e-07      js=5.1000e-07 \
      n=1.0000e+00 \
  dskip=no          tlev=0           tlevc=0         \
    jsw=6.0000e-13 \
     cj=8.3000e-04    cjsw=2.5000e-10 \
     fc=0.0000e+00    fcsw=0.000e+00 \
     mj=3.4000e-01    mjsw=2.3000e-01 \
     pb=6.9000e-01    pbsw=6.9000e-01     xti=2.0300e+00
ends nmosmw_3n

// ----------------------------------------------------------------------

// ----------------------------------------------------------------------
// Owner: austriamicrosystems
// HIT-Kit: Digital
// ************************ SIMULATION PARAMETERS ************************
//  ----------------------------------------------------------------------
//  format    : Spectre (Spectre Direct)
//  model     : MOS BSIM3v3
//  process   : C35
//  revision  : 1.0;
//  extracted : C18069; 28.08.2011; bse (5866)
//  doc#      : Eng-?? REV_0
//  ----------------------------------------------------------------------
//                          TYPICAL MEAN CONDITION
//
//  ----------------------------------------------------------------------
//
inline subckt nmosmw_4n ( d g s b )
parameters w=1.0e-6 l=1.0e-6 nrd=0.0 nrs=0.0 ad=0.0 as=0.0 pd=0.0 ps=0.0 ng=1
+ ws= w
+ ls= l
+ shk=1
//
if (modnm==1)
nmosmw_4n ( d g s b ) mosinsub w=ws l=ls nrd=6.0000e-07/ws nrs=6.0000e-07/ws ad=ad as=as pd=pd ps=ps m=ng
else
nmosmw_4n ( d s ) resistor r=1e30
notvalid paramtest errorif=(modnm==0) \
message="
***************************************************
*
* nmosm is not valid in selected process option.
*
***************************************************"
model mosinsub bsim3v3 version=3.2400e+00  type=n  capmod=3.0000e+00 \
 mobmod=1.0000e+00  nqsmod=0.0000e+00  noimod=3.0000e+00 \
   vbox=1.000e+03      k1=1.0000e+00 \
     k2=0.0000e+00      k3=-2.500e+00     k3b=-5.640e-02 \
    nch=1.4460e+17 vth0=7.1900e-01 \
   voff=-9.684e-02    dvt0=2.0510e+01    dvt1=1.0610e+00 \
   dvt2=2.5970e-02    keta=3.2000e-02 \
 pscbe1=1.0000e+30  pscbe2=1.0000e-06 \
 alpha0=5.5350e-08  alpha1=1.3930e-01   beta0=1.9570e+01 \
  dvt0w=1.0800e+01   dvt1w=3.0990e+06   dvt2w=1.4520e-01 \
     ua=4.5710e-10      ub=1.7380e-18      uc=5.7540e-11 \
u0=5.0600e+02 \
   dsub=5.0000e-01    eta0=4.0860e-02    etab=-1.000e-03 \
nfactor=8.6050e-01 \
     em=4.1000e+07    pclm=9.0000e-01 \
  drout=5.0000e-01 \
     a0=1.0000e+00      a1=0.0000e+00      a2=1.0000e+00 \
   pvag=6.0000e-02    vsat=6.3000e+04     ags=1.4990e-01      b0=2.0000e-08      b1=1.0000e-08 \
  delta=1.0000e-02 pdiblcb=9.7980e-01 \
pdiblc1=3.2000e-02 pdiblc2=1.6680e-03 \
     w0=3.3160e-08 \
    dlc=1.3960e-09 \
dwc=-2.884e-01*l+1.4740e-07    dwb=8.6800e-09     dwg=-3.770e-09 \
     ll=6.7850e-14      lw=0.0000e+00     lwl=0.0000e+00 \
    lln=1.0000e+00     lwn=1.0000e+00      wl=-1.989e-13 \
     ww=-1.514e-14     wwl=-1.321e-20     wln=1.0000e+00 \
     wr=1.0000e+00     wwn=1.0000e+00 \
     at=3.3000e+04     ute=-1.720e+00 \
    kt1=-4.180e-01     kt2=-4.560e-02    kt1l=0.0000e+00 \
    ua1=0.0000e+00     ub1=0.0000e+00     uc1=0.0000e+00 \
    prt=0.0000e+00 \
   cgso=1.0050e-10    cgdo=1.0050e-10    cgbo=1.6000e-08 \
   cgdl=1.0000e-10    cgsl=1.0000e-10  ckappa=2.9570e+00 \
     cf=0.0000e+00     elm=5.0000e+00 \
  xpart=1.0000e+00     clc=1.0000e-15     cle=6.0000e-01 \
\
   rdsw=2.7670e+03 \
   cdsc=0.0000e+00   cdscb=2.0000e-03   cdscd=0.0000e+00 \
   prwb=2.0000e-02    prwg=1.0000e-02     cit=0.0000e+00 \
tox=1.5000e-08 \
  ngate=1.0000e+00 \
    nlx=1.5690e-07 \
     xl=0.0000e+00      xw=0.0000e+00 \
     af=1.6290e+00      kf=9.1800e-26      ef=1.0000e+00 \
   noia=2.2450e+19    noib=1.1680e+05    noic=-1.680e-12 \
     rd=0.0000e+00      rs=0.0000e+00     rsh=7.9000e+01 \
   minr=1.000e-03 \
    rdc=0.0000e+00     rsc=0.0000e+00 lint=-2.104e-07 \
wint=-7.006e-07   ldif=0.000e+00    hdif=6.0000e-07 \
     xj=3.0000e-07      js=5.1000e-07 \
      n=1.0000e+00 \
  dskip=no          tlev=0           tlevc=0         \
    jsw=6.0000e-13 \
     cj=8.3000e-04    cjsw=2.5000e-10 \
     fc=0.0000e+00    fcsw=0.000e+00 \
     mj=3.4000e-01    mjsw=2.3000e-01 \
     pb=6.9000e-01    pbsw=6.9000e-01     xti=2.0300e+00
ends nmosmw_4n

// ----------------------------------------------------------------------

// ----------------------------------------------------------------------
// Owner: austriamicrosystems
// HIT-Kit: Digital
// ************************ SIMULATION PARAMETERS ************************
//  ----------------------------------------------------------------------
//  format    : Spectre (Spectre Direct)
//  model     : MOS BSIM3v3
//  process   : C35
//  revision  : 1.0;
//  extracted : C18069; 28.08.2011; bse (5866)
//  doc#      : Eng-?? REV_0
//  ----------------------------------------------------------------------
//                          TYPICAL MEAN CONDITION
//
//  ----------------------------------------------------------------------
//
inline subckt pmosw_2n ( d g s b )
parameters w=1.0e-6 l=1.0e-6 nrd=0.0 nrs=0.0 ad=0.0 as=0.0 pd=0.0 ps=0.0 ng=1
+ ws= w
+ ls= l
+ shk=1
//
if (modp==1)
pmosw_2n ( d g s b ) mosinsub w=ws l=ls nrd=8.0000e-07/ws nrs=8.0000e-07/ws ad=ad as=as pd=pd ps=ps m=ng
else
pmosw_2n ( d s ) resistor r=1e30
notvalid paramtest errorif=(modp==0) \
message="
***************************************************
*
* pmos is not valid in selected process option.
*
***************************************************"
model mosinsub bsim3v3 version=3.2400e+00  type=p  capmod=3.0000e+00 \
 mobmod=1.0000e+00  nqsmod=0.0000e+00  noimod=3.0000e+00 \
   vbox=1.000e+03      k1=3.3100e-01 \
     k2=0.0000e+00      k3=5.2000e+00     k3b=-1.000e+00 \
    nch=9.2400e+16 vth0=-7.440e-01 \
   voff=-1.640e-01    dvt0=2.2000e+00    dvt1=6.3470e-01 \
   dvt2=5.3690e-02    keta=-7.600e-03 \
 pscbe1=1.0000e+30  pscbe2=1.0000e-06 \
 alpha0=1.0000e-09  alpha1=1.1750e-02   beta0=2.2870e+01 \
  dvt0w=1.0090e-01   dvt1w=7.3400e+04   dvt2w=-6.310e-03 \
     ua=4.1690e-10      ub=1.9050e-18      uc=-3.631e-11 \
u0=1.7300e+02 \
   dsub=5.0000e-01    eta0=2.4000e-01    etab=-3.917e-03 \
nfactor=1.0000e+00 \
     em=4.1000e+07    pclm=3.3380e+00 \
  drout=5.0000e-01 \
     a0=9.0000e-01      a1=1.4440e-15      a2=5.0780e-01 \
   pvag=1.0000e-03    vsat=6.0900e+04     ags=2.1480e-01      b0=2.1920e-07      b1=0.0000e+00 \
  delta=1.0000e-02 pdiblcb=1.0000e-02 \
pdiblc1=8.9340e+02 pdiblc2=1.8000e-03 \
     w0=-1.500e-07 \
    dlc=-2.929e-08 \
dwc=-3.000e-01*l+1.5000e-07    dwb=-5.244e-09     dwg=-1.100e-08 \
     ll=3.5530e-15      lw=0.0000e+00     lwl=0.0000e+00 \
    lln=1.0000e+00     lwn=1.0000e+00      wl=-1.712e-12 \
     ww=-4.300e-14     wwl=-2.884e-21     wln=1.0000e+00 \
     wr=1.0000e+00     wwn=1.0000e+00 \
     at=3.3000e+04     ute=-1.300e+00 \
    kt1=-4.740e-01     kt2=-5.440e-02    kt1l=-1.600e-08 \
    ua1=0.0000e+00     ub1=-3.802e-19     uc1=0.0000e+00 \
    prt=0.0000e+00 \
   cgso=9.0000e-11    cgdo=9.0000e-11    cgbo=1.7000e-08 \
   cgdl=1.3550e-10    cgsl=1.3550e-10  ckappa=1.0000e-01 \
     cf=0.0000e+00     elm=5.0000e+00 \
  xpart=1.0000e+00     clc=1.0000e-15     cle=6.0000e-01 \
\
   rdsw=1.0660e+04 \
   cdsc=1.2000e-02   cdscb=9.0000e-03   cdscd=1.0000e-03 \
   prwb=1.9620e-02    prwg=-3.558e-02     cit=0.0000e+00 \
tox=7.7540e-09 \
  ngate=0.0000e+00 \
    nlx=3.0770e-08 \
     xl=0.0000e+00      xw=0.0000e+00 \
     af=1.4610e+00      kf=1.1910e-26      ef=1.0000e+00 \
   noia=5.2450e+17    noib=4.8160e+03    noic=8.0360e-13 \
     rd=0.0000e+00      rs=0.0000e+00     rsh=1.2900e+02 \
   minr=1.000e-03 \
    rdc=0.0000e+00     rsc=0.0000e+00 lint=-7.965e-07 \
wint=-1.959e-06   ldif=0.000e+00    hdif=8.0000e-07 \
     xj=3.0000e-07      js=2.8000e-07 \
      n=1.0000e+00 \
  dskip=no          tlev=0           tlevc=0         \
    jsw=3.7000e-13 \
     cj=1.3600e-03    cjsw=3.5000e-10 \
     fc=0.0000e+00    fcsw=0.000e+00 \
     mj=5.4000e-01    mjsw=4.6000e-01 \
     pb=1.0200e+00    pbsw=1.0200e+00     xti=1.9730e+00
ends pmosw_2n

// ----------------------------------------------------------------------

// ----------------------------------------------------------------------
// Owner: austriamicrosystems
// HIT-Kit: Digital
// ************************ SIMULATION PARAMETERS ************************
//  ----------------------------------------------------------------------
//  format    : Spectre (Spectre Direct)
//  model     : MOS BSIM3v3
//  process   : C35
//  revision  : 1.0;
//  extracted : C18069; 28.08.2011; bse (5866)
//  doc#      : Eng-?? REV_0
//  ----------------------------------------------------------------------
//                          TYPICAL MEAN CONDITION
//
//  ----------------------------------------------------------------------
//
inline subckt pmosw_3n ( d g s b )
parameters w=1.0e-6 l=1.0e-6 nrd=0.0 nrs=0.0 ad=0.0 as=0.0 pd=0.0 ps=0.0 ng=1
+ ws= w
+ ls= l
+ shk=1
//
if (modp==1)
pmosw_3n ( d g s b ) mosinsub w=ws l=ls nrd=8.0000e-07/ws nrs=8.0000e-07/ws ad=ad as=as pd=pd ps=ps m=ng
else
pmosw_3n ( d s ) resistor r=1e30
notvalid paramtest errorif=(modp==0) \
message="
***************************************************
*
* pmos is not valid in selected process option.
*
***************************************************"
model mosinsub bsim3v3 version=3.2400e+00  type=p  capmod=3.0000e+00 \
 mobmod=1.0000e+00  nqsmod=0.0000e+00  noimod=3.0000e+00 \
   vbox=1.000e+03      k1=3.3100e-01 \
     k2=0.0000e+00      k3=5.2000e+00     k3b=-1.000e+00 \
    nch=9.2400e+16 vth0=-7.440e-01 \
   voff=-1.640e-01    dvt0=2.2000e+00    dvt1=6.3470e-01 \
   dvt2=5.3690e-02    keta=-7.600e-03 \
 pscbe1=1.0000e+30  pscbe2=1.0000e-06 \
 alpha0=1.0000e-09  alpha1=1.1750e-02   beta0=2.2870e+01 \
  dvt0w=1.0090e-01   dvt1w=7.3400e+04   dvt2w=-6.310e-03 \
     ua=4.1690e-10      ub=1.9050e-18      uc=-3.631e-11 \
u0=1.7300e+02 \
   dsub=5.0000e-01    eta0=2.4000e-01    etab=-3.917e-03 \
nfactor=1.0000e+00 \
     em=4.1000e+07    pclm=3.5650e+00 \
  drout=5.0000e-01 \
     a0=9.0000e-01      a1=1.4440e-15      a2=5.0780e-01 \
   pvag=4.6400e+00    vsat=1.0000e+05     ags=3.8020e-01      b0=2.1920e-07      b1=0.0000e+00 \
  delta=1.0000e-02 pdiblcb=1.0000e+00 \
pdiblc1=8.3320e+00 pdiblc2=2.0670e-03 \
     w0=-1.500e-07 \
    dlc=-2.929e-08 \
dwc=-3.000e-01*l+1.5000e-07    dwb=-5.244e-09     dwg=-1.100e-08 \
     ll=3.5530e-15      lw=0.0000e+00     lwl=0.0000e+00 \
    lln=1.0000e+00     lwn=1.0000e+00      wl=-5.064e-13 \
     ww=-4.300e-14     wwl=-2.884e-21     wln=1.0000e+00 \
     wr=1.0000e+00     wwn=1.0000e+00 \
     at=3.3000e+04     ute=-1.300e+00 \
    kt1=-4.740e-01     kt2=-5.440e-02    kt1l=-1.600e-08 \
    ua1=0.0000e+00     ub1=-3.802e-19     uc1=0.0000e+00 \
    prt=0.0000e+00 \
   cgso=9.0000e-11    cgdo=9.0000e-11    cgbo=1.7000e-08 \
   cgdl=1.3550e-10    cgsl=1.3550e-10  ckappa=1.0000e-01 \
     cf=0.0000e+00     elm=5.0000e+00 \
  xpart=1.0000e+00     clc=1.0000e-15     cle=6.0000e-01 \
\
   rdsw=5.7750e+03 \
   cdsc=1.2000e-02   cdscb=9.0000e-03   cdscd=1.0000e-03 \
   prwb=1.9620e-02    prwg=-1.019e-02     cit=0.0000e+00 \
tox=7.7540e-09 \
  ngate=0.0000e+00 \
    nlx=3.0770e-08 \
     xl=0.0000e+00      xw=0.0000e+00 \
     af=1.4610e+00      kf=1.1910e-26      ef=1.0000e+00 \
   noia=5.2450e+17    noib=4.8160e+03    noic=8.0360e-13 \
     rd=0.0000e+00      rs=0.0000e+00     rsh=1.2900e+02 \
   minr=1.000e-03 \
    rdc=0.0000e+00     rsc=0.0000e+00 lint=-3.275e-07 \
wint=-9.593e-07   ldif=0.000e+00    hdif=8.0000e-07 \
     xj=3.0000e-07      js=2.8000e-07 \
      n=1.0000e+00 \
  dskip=no          tlev=0           tlevc=0         \
    jsw=3.7000e-13 \
     cj=1.3600e-03    cjsw=3.5000e-10 \
     fc=0.0000e+00    fcsw=0.000e+00 \
     mj=5.4000e-01    mjsw=4.6000e-01 \
     pb=1.0200e+00    pbsw=1.0200e+00     xti=1.9730e+00
ends pmosw_3n

// ----------------------------------------------------------------------

// ----------------------------------------------------------------------
// Owner: austriamicrosystems
// HIT-Kit: Digital
// ************************ SIMULATION PARAMETERS ************************
//  ----------------------------------------------------------------------
//  format    : Spectre (Spectre Direct)
//  model     : MOS BSIM3v3
//  process   : C35
//  revision  : 1.0;
//  extracted : C18069; 28.08.2011; bse (5866)
//  doc#      : Eng-?? REV_0
//  ----------------------------------------------------------------------
//                          TYPICAL MEAN CONDITION
//
//  ----------------------------------------------------------------------
//
inline subckt pmosw_4n ( d g s b )
parameters w=1.0e-6 l=1.0e-6 nrd=0.0 nrs=0.0 ad=0.0 as=0.0 pd=0.0 ps=0.0 ng=1
+ ws= w
+ ls= l
+ shk=1
//
if (modp==1)
pmosw_4n ( d g s b ) mosinsub w=ws l=ls nrd=8.0000e-07/ws nrs=8.0000e-07/ws ad=ad as=as pd=pd ps=ps m=ng
else
pmosw_4n ( d s ) resistor r=1e30
notvalid paramtest errorif=(modp==0) \
message="
***************************************************
*
* pmos is not valid in selected process option.
*
***************************************************"
model mosinsub bsim3v3 version=3.2400e+00  type=p  capmod=3.0000e+00 \
 mobmod=1.0000e+00  nqsmod=0.0000e+00  noimod=3.0000e+00 \
   vbox=1.000e+03      k1=3.3100e-01 \
     k2=0.0000e+00      k3=5.2000e+00     k3b=-1.000e+00 \
    nch=9.2400e+16 vth0=-7.440e-01 \
   voff=-1.640e-01    dvt0=2.2000e+00    dvt1=6.3470e-01 \
   dvt2=5.3690e-02    keta=-7.600e-03 \
 pscbe1=1.0000e+30  pscbe2=1.0000e-06 \
 alpha0=1.0000e-09  alpha1=1.1750e-02   beta0=2.2870e+01 \
  dvt0w=1.0090e-01   dvt1w=7.3400e+04   dvt2w=-6.310e-03 \
     ua=4.1690e-10      ub=1.9050e-18      uc=-3.631e-11 \
u0=1.7300e+02 \
   dsub=5.0000e-01    eta0=2.4000e-01    etab=-3.917e-03 \
nfactor=1.0000e+00 \
     em=4.1000e+07    pclm=3.5650e+00 \
  drout=5.0000e-01 \
     a0=9.0000e-01      a1=1.4440e-15      a2=5.0780e-01 \
   pvag=4.6400e+00    vsat=1.5480e+05     ags=3.8020e-01      b0=2.1920e-07      b1=0.0000e+00 \
  delta=1.0000e-02 pdiblcb=1.0000e+00 \
pdiblc1=5.6700e+00 pdiblc2=3.0670e-03 \
     w0=-1.500e-07 \
    dlc=-2.929e-08 \
dwc=-3.000e-01*l+1.5000e-07    dwb=-5.244e-09     dwg=-1.100e-08 \
     ll=3.5530e-15      lw=0.0000e+00     lwl=0.0000e+00 \
    lln=1.0000e+00     lwn=1.0000e+00      wl=-5.064e-13 \
     ww=-4.300e-14     wwl=-2.884e-21     wln=1.0000e+00 \
     wr=1.0000e+00     wwn=1.0000e+00 \
     at=3.3000e+04     ute=-1.300e+00 \
    kt1=-4.740e-01     kt2=-5.440e-02    kt1l=-1.600e-08 \
    ua1=0.0000e+00     ub1=-3.802e-19     uc1=0.0000e+00 \
    prt=0.0000e+00 \
   cgso=9.0000e-11    cgdo=9.0000e-11    cgbo=1.7000e-08 \
   cgdl=1.3550e-10    cgsl=1.3550e-10  ckappa=1.0000e-01 \
     cf=0.0000e+00     elm=5.0000e+00 \
  xpart=1.0000e+00     clc=1.0000e-15     cle=6.0000e-01 \
\
   rdsw=5.7750e+03 \
   cdsc=1.2000e-02   cdscb=9.0000e-03   cdscd=1.0000e-03 \
   prwb=1.9620e-02    prwg=-7.244e-03     cit=0.0000e+00 \
tox=7.7540e-09 \
  ngate=0.0000e+00 \
    nlx=3.0770e-08 \
     xl=0.0000e+00      xw=0.0000e+00 \
     af=1.4610e+00      kf=1.1910e-26      ef=1.0000e+00 \
   noia=5.2450e+17    noib=4.8160e+03    noic=8.0360e-13 \
     rd=0.0000e+00      rs=0.0000e+00     rsh=1.2900e+02 \
   minr=1.000e-03 \
    rdc=0.0000e+00     rsc=0.0000e+00 lint=-2.996e-07 \
wint=-6.844e-07   ldif=0.000e+00    hdif=8.0000e-07 \
     xj=3.0000e-07      js=2.8000e-07 \
      n=1.0000e+00 \
  dskip=no          tlev=0           tlevc=0         \
    jsw=3.7000e-13 \
     cj=1.3600e-03    cjsw=3.5000e-10 \
     fc=0.0000e+00    fcsw=0.000e+00 \
     mj=5.4000e-01    mjsw=4.6000e-01 \
     pb=1.0200e+00    pbsw=1.0200e+00     xti=1.9730e+00
ends pmosw_4n

// ----------------------------------------------------------------------

// ----------------------------------------------------------------------
// Owner: austriamicrosystems
// HIT-Kit: Digital
// ************************ SIMULATION PARAMETERS ************************
//  ----------------------------------------------------------------------
//  format    : Spectre (Spectre Direct)
//  model     : MOS BSIM3v3
//  process   : C35
//  revision  : 1.0;
//  extracted : C18069; 28.08.2011; bse (5866)
//  doc#      : Eng-?? REV_0
//  ----------------------------------------------------------------------
//                          TYPICAL MEAN CONDITION
//
//  ----------------------------------------------------------------------
//
inline subckt pmosmw_2n ( d g s b )
parameters w=1.0e-6 l=1.0e-6 nrd=0.0 nrs=0.0 ad=0.0 as=0.0 pd=0.0 ps=0.0 ng=1
+ ws= w
+ ls= l
+ shk=1
//
if (modpm==1)
pmosmw_2n ( d g s b ) mosinsub w=ws l=ls nrd=6.0000e-07/ws nrs=6.0000e-07/ws ad=ad as=as pd=pd ps=ps m=ng
else
pmosmw_2n ( d s ) resistor r=1e30
notvalid paramtest errorif=(modpm==0) \
message="
***************************************************
*
* pmosm is not valid in selected process option.
*
***************************************************"
model mosinsub bsim3v3 version=3.2400e+00  type=p  capmod=3.0000e+00 \
 mobmod=1.0000e+00  nqsmod=0.0000e+00  noimod=3.0000e+00 \
   vbox=1.000e+03      k1=5.4100e-01 \
     k2=0.0000e+00      k3=1.8000e+00     k3b=-1.000e+00 \
    nch=8.4790e+16 vth0=-1.055e+00 \
   voff=-1.148e-01    dvt0=1.7000e+00    dvt1=4.0100e-01 \
   dvt2=2.0050e-01    keta=2.0800e-02 \
 pscbe1=1.0000e+30  pscbe2=1.0000e-06 \
 alpha0=1.0000e-07  alpha1=3.1620e+00   beta0=4.2260e+01 \
  dvt0w=2.0000e-01   dvt1w=5.0000e+05   dvt2w=-3.200e+00 \
     ua=3.1000e-09      ub=2.2000e-19      uc=-8.318e-11 \
u0=2.2900e+02 \
   dsub=5.0000e-01    eta0=1.7900e-03    etab=-2.948e-02 \
nfactor=7.0460e-01 \
     em=4.1000e+07    pclm=4.9580e+00 \
  drout=5.0000e-01 \
     a0=1.0000e+00      a1=6.0520e-05      a2=2.2110e-01 \
   pvag=1.0000e+00    vsat=5.0470e+04     ags=1.4450e-01      b0=1.3800e-07      b1=0.0000e+00 \
  delta=1.0000e-02 pdiblcb=6.0000e-02 \
pdiblc1=2.5900e+04 pdiblc2=2.4430e-03 \
     w0=-1.800e-07 \
    dlc=-1.766e-08 \
dwc=-2.953e-01*l+1.4210e-07    dwb=-4.580e-09     dwg=-6.295e-09 \
     ll=0.0000e+00      lw=0.0000e+00     lwl=0.0000e+00 \
    lln=1.0000e+00     lwn=1.0000e+00      wl=-3.685e-12 \
     ww=-3.900e-14     wwl=-4.467e-21     wln=1.0000e+00 \
     wr=1.0000e+00     wwn=1.0000e+00 \
     at=7.9640e+04     ute=-1.492e+00 \
    kt1=-5.480e-01     kt2=-6.000e-02    kt1l=-2.600e-08 \
    ua1=-2.630e-10     ub1=-3.311e-18     uc1=0.0000e+00 \
    prt=0.0000e+00 \
   cgso=1.0010e-10    cgdo=1.0010e-10    cgbo=8.0000e-09 \
   cgdl=1.0770e-10    cgsl=1.0770e-10  ckappa=1.3700e+00 \
     cf=0.0000e+00     elm=5.0000e+00 \
  xpart=1.0000e+00     clc=1.0000e-15     cle=6.0000e-01 \
\
   rdsw=1.0820e+04 \
   cdsc=1.2140e-03   cdscb=2.9450e-04   cdscd=0.0000e+00 \
   prwb=5.0700e-02    prwg=7.0360e-02     cit=5.2590e-05 \
tox=1.5000e-08 \
  ngate=0.0000e+00 \
    nlx=1.2500e-07 \
     xl=0.0000e+00      xw=0.0000e+00 \
     af=1.6380e+00      kf=3.6250e-26      ef=1.0000e+00 \
   noia=5.8460e+17    noib=6.6230e+03    noic=7.7590e-13 \
     rd=0.0000e+00      rs=0.0000e+00     rsh=1.3000e+02 \
   minr=1.000e-03 \
    rdc=0.0000e+00     rsc=0.0000e+00 lint=-1.646e-06 \
wint=-2.751e-06   ldif=0.000e+00    hdif=6.0000e-07 \
     xj=3.0000e-07      js=2.8000e-07 \
      n=1.0000e+00 \
  dskip=no          tlev=0           tlevc=0         \
    jsw=3.7000e-13 \
     cj=1.3600e-03    cjsw=3.5000e-10 \
     fc=0.0000e+00    fcsw=0.000e+00 \
     mj=5.4000e-01    mjsw=4.6000e-01 \
     pb=1.0200e+00    pbsw=1.0200e+00     xti=1.9700e+00
ends pmosmw_2n

// ----------------------------------------------------------------------

// ----------------------------------------------------------------------
// Owner: austriamicrosystems
// HIT-Kit: Digital
// ************************ SIMULATION PARAMETERS ************************
//  ----------------------------------------------------------------------
//  format    : Spectre (Spectre Direct)
//  model     : MOS BSIM3v3
//  process   : C35
//  revision  : 1.0;
//  extracted : C18069; 28.08.2011; bse (5866)
//  doc#      : Eng-?? REV_0
//  ----------------------------------------------------------------------
//                          TYPICAL MEAN CONDITION
//
//  ----------------------------------------------------------------------
//
inline subckt pmosmw_3n ( d g s b )
parameters w=1.0e-6 l=1.0e-6 nrd=0.0 nrs=0.0 ad=0.0 as=0.0 pd=0.0 ps=0.0 ng=1
+ ws= w
+ ls= l
+ shk=1
//
if (modpm==1)
pmosmw_3n ( d g s b ) mosinsub w=ws l=ls nrd=6.0000e-07/ws nrs=6.0000e-07/ws ad=ad as=as pd=pd ps=ps m=ng
else
pmosmw_3n ( d s ) resistor r=1e30
notvalid paramtest errorif=(modpm==0) \
message="
***************************************************
*
* pmosm is not valid in selected process option.
*
***************************************************"
model mosinsub bsim3v3 version=3.2400e+00  type=p  capmod=3.0000e+00 \
 mobmod=1.0000e+00  nqsmod=0.0000e+00  noimod=3.0000e+00 \
   vbox=1.000e+03      k1=5.4100e-01 \
     k2=0.0000e+00      k3=1.8000e+00     k3b=-1.000e+00 \
    nch=8.4790e+16 vth0=-1.055e+00 \
   voff=-1.148e-01    dvt0=1.7000e+00    dvt1=4.0100e-01 \
   dvt2=2.0050e-01    keta=2.0800e-02 \
 pscbe1=1.0000e+30  pscbe2=1.0000e-06 \
 alpha0=1.0000e-07  alpha1=3.1620e+00   beta0=4.2260e+01 \
  dvt0w=2.0000e-01   dvt1w=5.0000e+05   dvt2w=-3.200e+00 \
     ua=3.1000e-09      ub=2.2000e-19      uc=-1.553e-10 \
u0=2.2900e+02 \
   dsub=5.0000e-01    eta0=1.7900e-03    etab=-2.948e-02 \
nfactor=7.0460e-01 \
     em=4.1000e+07    pclm=4.9580e+00 \
  drout=5.0000e-01 \
     a0=1.0000e+00      a1=6.0520e-05      a2=2.2110e-01 \
   pvag=-1.500e+00    vsat=4.9050e+04     ags=1.4450e-01      b0=1.3800e-07      b1=0.0000e+00 \
  delta=1.0000e-02 pdiblcb=6.0000e-02 \
pdiblc1=2.6560e+02 pdiblc2=2.6870e-03 \
     w0=-1.800e-07 \
    dlc=-1.766e-08 \
dwc=-2.953e-01*l+1.4210e-07    dwb=-4.580e-09     dwg=-6.295e-09 \
     ll=0.0000e+00      lw=0.0000e+00     lwl=0.0000e+00 \
    lln=1.0000e+00     lwn=1.0000e+00      wl=-2.315e-12 \
     ww=-3.900e-14     wwl=-4.467e-21     wln=1.0000e+00 \
     wr=1.0000e+00     wwn=1.0000e+00 \
     at=7.9640e+04     ute=-1.492e+00 \
    kt1=-5.480e-01     kt2=-6.000e-02    kt1l=-2.600e-08 \
    ua1=-2.630e-10     ub1=-3.311e-18     uc1=0.0000e+00 \
    prt=0.0000e+00 \
   cgso=1.0010e-10    cgdo=1.0010e-10    cgbo=8.0000e-09 \
   cgdl=1.0770e-10    cgsl=1.0770e-10  ckappa=1.3700e+00 \
     cf=0.0000e+00     elm=5.0000e+00 \
  xpart=1.0000e+00     clc=1.0000e-15     cle=6.0000e-01 \
\
   rdsw=1.1340e+04 \
   cdsc=1.2140e-03   cdscb=2.9450e-04   cdscd=0.0000e+00 \
   prwb=-5.503e-02    prwg=1.5470e-02     cit=5.2590e-05 \
tox=1.5000e-08 \
  ngate=0.0000e+00 \
    nlx=1.2500e-07 \
     xl=0.0000e+00      xw=0.0000e+00 \
     af=1.6380e+00      kf=3.6250e-26      ef=1.0000e+00 \
   noia=5.8460e+17    noib=6.6230e+03    noic=7.7590e-13 \
     rd=0.0000e+00      rs=0.0000e+00     rsh=1.3000e+02 \
   minr=1.000e-03 \
    rdc=0.0000e+00     rsc=0.0000e+00 lint=-1.020e-06 \
wint=-1.770e-06   ldif=0.000e+00    hdif=6.0000e-07 \
     xj=3.0000e-07      js=2.8000e-07 \
      n=1.0000e+00 \
  dskip=no          tlev=0           tlevc=0         \
    jsw=3.7000e-13 \
     cj=1.3600e-03    cjsw=3.5000e-10 \
     fc=0.0000e+00    fcsw=0.000e+00 \
     mj=5.4000e-01    mjsw=4.6000e-01 \
     pb=1.0200e+00    pbsw=1.0200e+00     xti=1.9700e+00
ends pmosmw_3n

// ----------------------------------------------------------------------

// ----------------------------------------------------------------------
// Owner: austriamicrosystems
// HIT-Kit: Digital
// ************************ SIMULATION PARAMETERS ************************
//  ----------------------------------------------------------------------
//  format    : Spectre (Spectre Direct)
//  model     : MOS BSIM3v3
//  process   : C35
//  revision  : 1.0;
//  extracted : C18069; 28.08.2011; bse (5866)
//  doc#      : Eng-?? REV_0
//  ----------------------------------------------------------------------
//                          TYPICAL MEAN CONDITION
//
//  ----------------------------------------------------------------------
//
inline subckt pmosmw_4n ( d g s b )
parameters w=1.0e-6 l=1.0e-6 nrd=0.0 nrs=0.0 ad=0.0 as=0.0 pd=0.0 ps=0.0 ng=1
+ ws= w
+ ls= l
+ shk=1
//
if (modpm==1)
pmosmw_4n ( d g s b ) mosinsub w=ws l=ls nrd=6.0000e-07/ws nrs=6.0000e-07/ws ad=ad as=as pd=pd ps=ps m=ng
else
pmosmw_4n ( d s ) resistor r=1e30
notvalid paramtest errorif=(modpm==0) \
message="
***************************************************
*
* pmosm is not valid in selected process option.
*
***************************************************"
model mosinsub bsim3v3 version=3.2400e+00  type=p  capmod=3.0000e+00 \
 mobmod=1.0000e+00  nqsmod=0.0000e+00  noimod=3.0000e+00 \
   vbox=1.000e+03      k1=5.4100e-01 \
     k2=0.0000e+00      k3=1.8000e+00     k3b=-1.000e+00 \
    nch=8.4790e+16 vth0=-1.055e+00 \
   voff=-1.148e-01    dvt0=1.7000e+00    dvt1=4.0100e-01 \
   dvt2=2.0050e-01    keta=2.0800e-02 \
 pscbe1=1.0000e+30  pscbe2=1.0000e-06 \
 alpha0=1.0000e-07  alpha1=3.1620e+00   beta0=4.2260e+01 \
  dvt0w=2.0000e-01   dvt1w=5.0000e+05   dvt2w=-3.200e+00 \
     ua=3.1000e-09      ub=2.2000e-19      uc=-8.318e-11 \
u0=2.2900e+02 \
   dsub=5.0000e-01    eta0=1.7900e-03    etab=-2.948e-02 \
nfactor=7.0460e-01 \
     em=4.1000e+07    pclm=4.9580e+00 \
  drout=5.0000e-01 \
     a0=1.0000e+00      a1=6.0520e-05      a2=2.2110e-01 \
   pvag=-1.500e+00    vsat=6.7470e+04     ags=1.4450e-01      b0=1.3800e-07      b1=0.0000e+00 \
  delta=1.0000e-02 pdiblcb=6.0000e-02 \
pdiblc1=2.8350e+01 pdiblc2=3.8950e-03 \
     w0=-1.800e-07 \
    dlc=-1.766e-08 \
dwc=-2.953e-01*l+1.4210e-07    dwb=-4.580e-09     dwg=-6.295e-09 \
     ll=0.0000e+00      lw=0.0000e+00     lwl=0.0000e+00 \
    lln=1.0000e+00     lwn=1.0000e+00      wl=-1.534e-12 \
     ww=-3.900e-14     wwl=-4.467e-21     wln=1.0000e+00 \
     wr=1.0000e+00     wwn=1.0000e+00 \
     at=7.9640e+04     ute=-1.492e+00 \
    kt1=-5.480e-01     kt2=-6.000e-02    kt1l=-2.600e-08 \
    ua1=-2.630e-10     ub1=-3.311e-18     uc1=0.0000e+00 \
    prt=0.0000e+00 \
   cgso=1.0010e-10    cgdo=1.0010e-10    cgbo=8.0000e-09 \
   cgdl=1.0770e-10    cgsl=1.0770e-10  ckappa=1.3700e+00 \
     cf=0.0000e+00     elm=5.0000e+00 \
  xpart=1.0000e+00     clc=1.0000e-15     cle=6.0000e-01 \
\
   rdsw=6.6990e+03 \
   cdsc=1.2140e-03   cdscb=2.9450e-04   cdscd=0.0000e+00 \
   prwb=5.0700e-02    prwg=7.7360e-02     cit=5.2590e-05 \
tox=1.5000e-08 \
  ngate=0.0000e+00 \
    nlx=1.2500e-07 \
     xl=0.0000e+00      xw=0.0000e+00 \
     af=1.6380e+00      kf=3.6250e-26      ef=1.0000e+00 \
   noia=5.8460e+17    noib=6.6230e+03    noic=7.7590e-13 \
     rd=0.0000e+00      rs=0.0000e+00     rsh=1.3000e+02 \
   minr=1.000e-03 \
    rdc=0.0000e+00     rsc=0.0000e+00 lint=-7.278e-07 \
wint=-1.000e-06   ldif=0.000e+00    hdif=6.0000e-07 \
     xj=3.0000e-07      js=2.8000e-07 \
      n=1.0000e+00 \
  dskip=no          tlev=0           tlevc=0         \
    jsw=3.7000e-13 \
     cj=1.3600e-03    cjsw=3.5000e-10 \
     fc=0.0000e+00    fcsw=0.000e+00 \
     mj=5.4000e-01    mjsw=4.6000e-01 \
     pb=1.0200e+00    pbsw=1.0200e+00     xti=1.9700e+00
ends pmosmw_4n

// ----------------------------------------------------------------------

// ----------------------------------------------------------------------
// Owner: austriamicrosystems
// HIT-Kit: Digital
//************************ SIMULATION PARAMETERS ************************
// ----------------------------------------------------------------------
// format    : Spectre
// model     : MODNRF
// process   : CS ADFI
// revision  : 3.1;
// extracted : CSD C64330.04e3; 2002-09; kmo(5966)
// doc#      : ENG-188 REV_5
// ----------------------------------------------------------------------
//                         TYPICAL MEAN CONDITION
// ----------------------------------------------------------------------
//
//  RF CMOS TRANSISTOR MODEL
//
//-----------------------------------------------------------------------
inline subckt modnrf ( d g s b )
parameters w=1.0e-6 l=1.0e-6 nrd=0.0 nrs=0.0 ad=0.0 as=0.0 pd=0.0 ps=0.0 ng=1
+ mmvth_modnrf=0.0 mmu0_modnrf=0.0
+ dvthmat=(mv_modnrf53+mmvth_modnrf)*(0.67e-08/sqrt(l*w*ng)) dumat=(mu_modnrf53+mmu0_modnrf)*(4.9e-9/sqrt(l*w*ng))
// //
if (modnrf==1){
// --------- Gate network ------------------------------
lg  (g 20 ) inductor l=1.000e-15
rg  (20 21 ) resistor r=((6.895e-04/w+4.758e+01 )/ng+(3.726e+05*w+2.740e+00)) isnoisy=yes
//
// --------- Drain network -----------------------------
ldrain ( d 13 ) inductor l=1.000e-15
rdrain ( 13 11 ) resistor r=(3.320e-04/(w*ng)+1.669e-01) isnoisy=yes
//
// --------- Source network -----------------------------
lsource ( s 33 ) inductor l=1.000e-15
rsource ( 33 31 ) resistor r=(3.320e-04/(w*ng)+1.669e-01) isnoisy=yes
//
// --------- Substrate network -------------------------
// Diodes are for n-type or p-type MOS transistors
//
djdb  ( 12 11 ) bulk_diode area=ad*ng perim=pd*ng
djsb  ( 32 31 ) bulk_diode area=as*ng perim=ps*ng
//
rsub1 ( 12 b ) resistor r=((0.000e+00/w+0.000e+00)/ng+(9.524e+06*w+(4.156e+01))) isnoisy=yes
rsub2 ( 32 b ) resistor r=((0.000e+00/w+0.000e+00)/ng+(9.524e+06*w+(4.156e+01))) isnoisy=yes
//
// --------- Ideal mos transistor ----------------------
modnrf ( 11 21 31 b ) mosinsub l=l w=w*ng ad=0.0 as=0.0 pd=0.0 ps=0.0 nrd=0 nrs=0
}else
modnrf ( d s ) resistor r=1e30
notvalid paramtest errorif=(modnrf==0) \
message="
***************************************************
*
* nmosrf is not valid in selected process option.
*
***************************************************"
// Intrinsic MOS transistor
model mosinsub bsim3v3 version=3.1 type=n  capmod=2.0000e+00 \
 mobmod=1.0000e+00  nqsmod=0.0000e+00  noimod=3 \
   vbox=1.000e+03      k1=6.0444e-01 \
     k2=2.9447e-03      k3=-1.715e+00     k3b=6.3250e-01 \
    nch=2.3100e+17 vth0=4.6550e-01 \
   voff=-5.719e-02    dvt0=2.2270e+01    dvt1=1.0510e+00 \
   dvt2=3.3930e-03    keta=-6.207e-04 \
 pscbe1=2.7560e+08  pscbe2=9.6450e-06 \
 alpha0=0.0000e+00   beta0=3.0000e+01 \
  dvt0w=0.0000e+00   dvt1w=0.0000e+00   dvt2w=0.0000e+00 \
     ua=1.0000e-12      ub=4.8510e-18      uc=5.7560e-11 \
u0=6.2680e+02 \
   dsub=5.0000e-01    eta0=3.0850e-02    etab=-3.947e-02 \
nfactor=1.1190e-01 \
     em=4.1000e+07    pclm=1.5270e+00 \
  drout=5.0000e-01 \
     a0=2.2080e+00      a1=0.0000e+00      a2=1.0000e+00 \
   pvag=0.0000e+00    vsat=7.5800e+04     ags=2.4900e-01      b0=-1.765e-08      b1=0.0000e+00 \
  delta=1.0000e-02 pdiblcb=2.5830e-01 \
pdiblc1=1.0760e-01 pdiblc2=1.4530e-03 \
     w0=1.1840e-07 \
    dlc=6.6050e-08 \
    dwc=2.6760e-08     dwb=0.0000e+00     dwg=0.0000e+00 \
     ll=0.000e+00      lw=0.000e+00     lwl=0.000e+00 \
    lln=1.000e+00     lwn=1.000e+00      wl=0.0000e+00 \
     ww=0.0000e+00     wwl=0.0000e+00     wln=1.0000e+00 \
    wwn=1.0000e+00 \
     at=3.3000e+04     ute=-1.800e+00 \
    kt1=-3.302e-01     kt2=2.2000e-02    kt1l=0.0000e+00 \
    ua1=0.0000e+00     ub1=0.0000e+00     uc1=0.0000e+00 \
    prt=0.0000e+00 \
   cgso=1.8730e-10    cgdo=1.8730e-10    cgbo=1.1000e-10 \
   cgdl=1.0680e-10    cgsl=1.0680e-10  ckappa=6.0000e-01 \
     cf=0.0000e+00     elm=5.0000e+00 \
  xpart=1.0000e+00     clc=1.0000e-15     cle=6.0000e-01 \
\
   rdsw=0.0000e+00 \
   cdsc=0.0000e+00   cdscb=0.0000e+00   cdscd=8.4480e-05 \
   prwb=0.0000e+00    prwg=0.0000e+00     cit=1.0000e-03 \
tox=7.7000e-09 \
  ngate=0.0000e+00 \
    nlx=1.9180e-07 \
     xl=0.0000e+00      xw=0.0000e+00 \
     af=1.5070e+00      kf=2.1700e-26      ef=1.0000e+00 \
   noia=1.1210e+19    noib=5.3360e+04    noic=-5.892e-13 \
     rd=0.0000e+00      rs=0.0000e+00     rsh=8.2000e+01 \
   minr=1.000e-03 \
    rdc=0.0000e+00     rsc=0.0000e+00 lint=8.2850e-09 \
wint=2.6760e-08   ldif=0.000e+00    hdif=6.0000e-07 \
     xj=3.0000e-07      js=5.1000e-07 \
      n=1.0000e+00 \
  dskip=no          tlev=0           tlevc=0         \
    jsw=0.0000e+00 \
     cj=0.0000e+00    cjsw=0.0000e+00 \
     fc=0.0000e+00    fcsw=0.000e+00 \
     mj=3.1000e-01    mjsw=1.9000e-01 \
     pb=6.9000e-01    pbsw=6.9000e-01
// Bulk Diode Model
model bulk_diode diode level=1 dskip=no \
     is=5.100e-07      isw=0.600e-12       n=1.0000000       ns=1.0000000   \
    cjo=1.580e-03       m=3.100e-01 \
    cjsw=0.000e+00       mjsw=2.011E-01 \
     fc=0.000e+00      tt=0.000e+00      vj=6.900e-01      vjsw=6.672E-01  \
     kf=0.000e+00      eg=1.11e+00     xti=2.026e+00      af=1.000e+00
ends modnrf
// ----------------------------------------------------------------------
// ----------------------------------------------------------------------
// Owner: austriamicrosystems
// HIT-Kit: Digital
//************************ SIMULATION PARAMETERS ************************
// ----------------------------------------------------------------------
// format    : Spectre
// model     : MODPRF
// process   : C/B/S 35
// revision  : 3.1;
// extracted : C35B3 B11634.L1 04PA3; 2002-09; kmo(5966)
// doc#      : ENG-188 REV_5
// ----------------------------------------------------------------------
//                         TYPICAL MEAN CONDITION
// ----------------------------------------------------------------------
//
//  RF CMOS TRANSISTOR MODEL
//
//-----------------------------------------------------------------------
inline subckt modprf ( d g s b )
parameters w=1.0e-6 l=1.0e-6 nrd=0.0 nrs=0.0 ad=0.0 as=0.0 pd=0.0 ps=0.0 ng=1
+ mmvth_modprf=0.0 mmu0_modprf=0.0
+ dvthmat=(mv_modprf53+mmvth_modprf)*(1.03e-08/sqrt(l*w*ng)) dumat=(mu_modprf53+mmu0_modprf)*(7.1e-9/sqrt(l*w*ng))
// //
if (modprf==1){
// --------- Gate network ------------------------------
lg  (g 20 ) inductor l=1.000e-15
rg  (20 21 ) resistor r=((-5.800e-04/w+2.884e+02 )/ng+(-5.394e+05*w+1.596e+00)) isnoisy=yes
//
// --------- Drain network -----------------------------
ldrain ( d 13 ) inductor l=1.000e-15
rdrain ( 13 11 ) resistor r=(8.051e-04/(w*ng)+1.731e+00) isnoisy=yes
//
// --------- Source network -----------------------------
lsource ( s 33 ) inductor l=1.000e-15
rsource ( 33 31 ) resistor r=(8.051e-04/(w*ng)+1.731e+00) isnoisy=yes
//
// --------- Substrate network -------------------------
// Diodes are for n-type or p-type MOS transistors
//
djdb  ( 11 12 ) bulk_diode area=ad*ng perim=pd*ng
djsb  ( 31 32 ) bulk_diode area=as*ng perim=ps*ng
//
rsub1 ( 12 b ) resistor r=((1.064e-04/w+1.682e+02)/ng+(1.724e+06*w+(-2.292e+00))) isnoisy=yes
rsub2 ( 32 b ) resistor r=((1.064e-04/w+1.682e+02)/ng+(1.724e+06*w+(-2.292e+00))) isnoisy=yes
//
// --------- Ideal mos transistor ----------------------
modprf ( 11 21 31 b ) mosinsub l=l w=w*ng ad=0.0 as=0.0 pd=0.0 ps=0.0 nrd=0 nrs=0
}else
modprf ( d s ) resistor r=1e30
notvalid paramtest errorif=(modprf==0) \
message="
***************************************************
*
* pmosrf is not valid in selected process option.
*
***************************************************"
// Intrinsic MOS transistor
model mosinsub bsim3v3 version=3.1 type=p  capmod=2.0000e+00 \
 mobmod=1.0000e+00  nqsmod=0.0000e+00  noimod=3 \
   vbox=1.000e+03      k1=1.3514e-02 \
     k2=1.2501e-01      k3=1.1030e+01     k3b=-7.580e-01 \
    nch=1.4580e+17 vth0=-7.359e-01 \
   voff=-1.170e-01    dvt0=1.6500e+00    dvt1=3.8680e-01 \
   dvt2=1.6590e-02    keta=-1.440e-02 \
 pscbe1=5.0000e+09  pscbe2=1.0000e-04 \
 alpha0=0.0000e+00   beta0=3.0000e+01 \
  dvt0w=1.8790e-01   dvt1w=7.3350e+04   dvt2w=-6.312e-03 \
     ua=5.3940e-10      ub=3.9760e-19      uc=1.0000e-20 \
u0=1.3230e+02 \
   dsub=5.0000e-01    eta0=2.4800e-01    etab=-3.917e-03 \
nfactor=1.2140e+00 \
     em=4.1000e+07    pclm=1.8290e+00 \
  drout=5.0000e-01 \
     a0=5.8500e-01      a1=0.0000e+00      a2=1.0000e+00 \
   pvag=0.0000e+00    vsat=4.8240e+04     ags=2.4680e-01      b0=8.8320e-08      b1=0.0000e+00 \
  delta=1.0000e-02 pdiblcb=1.0000e+00 \
pdiblc1=1.0000e-04 pdiblc2=1.0000e-20 \
     w0=1.0000e-10 \
    dlc=5.6730e-08 \
    dwc=3.4490e-08     dwb=0.0000e+00     dwg=0.0000e+00 \
     ll=0.000e+00      lw=0.000e+00     lwl=0.000e+00 \
    lln=1.000e+00     lwn=1.000e+00      wl=0.0000e+00 \
     ww=1.8940e-16     wwl=-1.981e-21     wln=1.0000e+00 \
    wwn=1.0400e+00 \
     at=3.3000e+04     ute=-1.300e+00 \
    kt1=-5.403e-01     kt2=2.2000e-02    kt1l=0.0000e+00 \
    ua1=0.0000e+00     ub1=0.0000e+00     uc1=0.0000e+00 \
    prt=0.0000e+00 \
   cgso=1.0000e-12    cgdo=1.0000e-12    cgbo=1.1000e-10 \
   cgdl=2.5880e-10    cgsl=2.5880e-10  ckappa=6.0000e-01 \
     cf=0.0000e+00     elm=5.0000e+00 \
  xpart=1.0000e+00     clc=1.0000e-15     cle=6.0000e-01 \
\
   rdsw=0.0000e+00 \
   cdsc=2.5890e-03   cdscb=2.9430e-04   cdscd=4.3700e-04 \
   prwb=-9.731e-02    prwg=1.4770e-01     cit=0.0000e+00 \
tox=7.7540e-09 \
  ngate=0.0000e+00 \
    nlx=1.7700e-07 \
     xl=0.0000e+00      xw=0.0000e+00 \
     af=1.4610e+00      kf=1.1910e-26      ef=1.0000e+00 \
   noia=5.2450e+17    noib=4.8160e+03    noic=8.0360e-13 \
     rd=0.0000e+00      rs=0.0000e+00     rsh=1.2900e+02 \
   minr=1.000e-03 \
    rdc=0.0000e+00     rsc=0.0000e+00 lint=-1.164e-08 \
wint=3.4490e-08   ldif=0.000e+00    hdif=8.0000e-07 \
     xj=3.0000e-07      js=2.8000e-07 \
      n=1.0000e+00 \
  dskip=no          tlev=0           tlevc=0         \
    jsw=3.7000e-13 \
     cj=0.0000e+00    cjsw=0.0000e+00 \
     fc=0.0000e+00    fcsw=0.000e+00 \
     mj=5.6000e-01    mjsw=4.3000e-01 \
     pb=1.0200e+00    pbsw=1.0200e+00
// Bulk Diode Model
model bulk_diode diode level=1 dskip=no \
     is=2.800e-07      isw=3.700e-13       n=1.0000000       ns=1.0000000   \
    cjo=1.526e-03       m=1.176e-01 \
    cjsw=0.000e+00       mjsw=4.300e-01 \
     fc=0.000e+00      tt=0.000e+00      vj=1.020e+00      vjsw=1.020e+00  \
     kf=0.000e+00      eg=1.11e+00     xti=1.973e+00      af=1.000e+00
ends modprf
// ----------------------------------------------------------------------
//-------------- END OF Section ------------------
endsection
section cmoswp
//
// ----------------------------------------------------------------------
// Owner: austriamicrosystems
// HIT-Kit: Digital
// ************************ SIMULATION PARAMETERS ************************
//  ----------------------------------------------------------------------
//  format    : Spectre (Spectre Direct)
//  model     : MOS BSIM3v3
//  process   : C35
//  revision  : 4.0;
//  extracted : B10866 ; 2002-12; ese(5487)
//  doc#      : ENG-182 REV_6
//  ----------------------------------------------------------------------
//                         WORST CASE POWER CONDITION
//
//  ----------------------------------------------------------------------
//
inline subckt modn ( d g s b )
parameters w=1.0e-6 l=1.0e-6 nrd=0.0 nrs=0.0 ad=0.0 as=0.0 pd=0.0 ps=0.0 ng=1
+ ws= w
+ ls= l
+ shk=1
+ dvthmat=(mv_modn)*(0.67e-08/sqrt(ls*ws*ng)) dumat=(mu_modn)*(4.9e-9/sqrt(ls*ws*ng))
//
if (modn==1)
modn ( d g s b ) mosinsub w=ws l=ls nrd=nrd nrs=nrs ad=ad as=as pd=pd ps=ps m=ng
else
modn ( d s ) resistor r=1e30
notvalid paramtest errorif=(modn==0) \
message="
***************************************************
*
* nmos is not valid in selected process option.
*
***************************************************"
model mosinsub bsim3v3 version=3.2400e+00  type=n  capmod=2.0000e+00 \
 mobmod=1.0000e+00  nqsmod=0.0000e+00  noimod=3 \
   vbox=1.000e+03      k1=3.5516e-01 \
     k2=4.6758e-02      k3=-1.136e+00     k3b=-4.399e-01 \
    nch=2.1280e+17 vth0=3.5790e-01+dvthmat \
   voff=-8.925e-02    dvt0=5.0000e+01    dvt1=1.0390e+00 \
   dvt2=-8.375e-03    keta=2.0320e-02 \
 pscbe1=1.0000e+30  pscbe2=1.0000e-06 \
 alpha0=2.6000e-06  alpha1=5.0000e+00   beta0=2.1000e+01 \
  dvt0w=1.0890e-01   dvt1w=6.6710e+04   dvt2w=-1.352e-02 \
     ua=4.7050e-12      ub=2.1370e-18      uc=1.0000e-20 \
u0=5.0020e+02+(5.0020e+02)*dumat \
   dsub=5.0000e-01    eta0=1.4150e-02    etab=-1.221e-01 \
nfactor=4.1360e-01 \
     em=4.1000e+07    pclm=6.9480e-01 \
  drout=5.0000e-01 \
     a0=2.5410e+00      a1=0.0000e+00      a2=1.0000e+00 \
   pvag=0.0000e+00    vsat=1.3380e+05     ags=2.4080e-01      b0=4.3010e-09      b1=0.0000e+00 \
  delta=1.4420e-02 pdiblcb=3.2220e-01 \
pdiblc1=3.5710e-01 pdiblc2=2.0650e-03 \
     w0=2.6730e-07 \
    dlc=3.0000e-08 \
    dwc=9.4030e-08     dwb=0.0000e+00     dwg=0.0000e+00 \
     ll=0.000e+00      lw=0.000e+00     lwl=0.000e+00 \
    lln=1.000e+00     lwn=1.000e+00      wl=0.0000e+00 \
     ww=-1.297e-14     wwl=-9.411e-21     wln=1.0000e+00 \
     wr=1.0000e+00     wwn=1.0000e+00 \
     at=3.3000e+04     ute=-1.800e+00 \
    kt1=-3.302e-01     kt2=2.2000e-02    kt1l=0.0000e+00 \
    ua1=0.0000e+00     ub1=0.0000e+00     uc1=0.0000e+00 \
    prt=0.0000e+00 \
   cgso=1.2000e-10    cgdo=1.2000e-10    cgbo=1.0000e-10 \
   cgdl=1.1500e-10    cgsl=1.1500e-10  ckappa=6.0000e-01 \
     cf=0.0000e+00     elm=5.0000e+00 \
  xpart=1.0000e+00     clc=1.0000e-15     cle=6.0000e-01 \
   noff=1.0000e+00  voffcv=0.0000e+00 \
   rdsw=3.4490e+02 \
   cdsc=0.0000e+00   cdscb=1.5000e-03   cdscd=1.0000e-03 \
   prwb=-2.416e-01    prwg=0.0000e+00     cit=4.4410e-04 \
tox=7.1000e-09 \
  ngate=0.0000e+00 \
    nlx=1.8880e-07 \
     xl=-5.000e-08      xw=5.0000e-08 \
     af=1.3760e+00      kf=3.3960e-26      ef=1.0000e+00 \
   noia=1.3990e+20    noib=2.7070e+05    noic=-4.680e-12 \
     rd=0.0000e+00      rs=0.0000e+00     rsh=5.5000e+01 \
   minr=1.000e-03 \
    rdc=0.0000e+00     rsc=0.0000e+00 lint=-5.005e-08 \
wint=9.4030e-08   ldif=0.000e+00    hdif=8.0000e-07 \
     xj=3.0000e-07      js=5.1000e-07 \
      n=1.0000e+00 \
  dskip=no          tlev=0           tlevc=0         \
    jsw=6.0000e-13 \
     cj=8.2700e-04    cjsw=2.2000e-10 \
     fc=0.0000e+00    fcsw=0.000e+00 \
     mj=3.4000e-01    mjsw=2.3000e-01 \
     pb=6.9000e-01    pbsw=6.9000e-01     xti=2.0260e+00
ends modn

// ----------------------------------------------------------------------
// ----------------------------------------------------------------------
// Owner: austriamicrosystems
// HIT-Kit: Digital
// ************************ SIMULATION PARAMETERS ************************
//  ----------------------------------------------------------------------
//  format    : Spectre (Spectre Direct)
//  model     : MOS BSIM3v3
//  process   : C35
//  revision  : 4.1;
//  extracted : B11004 ; 2002-12; ese(5487)
//  doc#      : ENG-182 REV_6
//  ----------------------------------------------------------------------
//                         WORST CASE POWER CONDITION
//
//  ----------------------------------------------------------------------
//
inline subckt modnm ( d g s b )
parameters w=1.0e-6 l=1.0e-6 nrd=0.0 nrs=0.0 ad=0.0 as=0.0 pd=0.0 ps=0.0 ng=1
+ ws= w
+ ls= l
+ shk=1
+ dvthmat=(mv_modnm)*(1.03e-08/sqrt(ls*ws*ng)) dumat=(mu_modnm)*(3.5e-9/sqrt(ls*ws*ng))
//
if (modnm==1)
modnm ( d g s b ) mosinsub w=ws l=ls nrd=nrd nrs=nrs ad=ad as=as pd=pd ps=ps m=ng
else
modnm ( d s ) resistor r=1e30
notvalid paramtest errorif=(modnm==0) \
message="
***************************************************
*
* nmosm is not valid in selected process option.
*
***************************************************"
model mosinsub bsim3v3 version=3.2400e+00  type=n  capmod=2.0000e+00 \
 mobmod=1.0000e+00  nqsmod=0.0000e+00  noimod=3 \
   vbox=1.000e+03      k1=5.7395e-01 \
     k2=1.2009e-01      k3=-3.776e+00     k3b=-7.691e-02 \
    nch=2.0710e+17 vth0=6.2950e-01+dvthmat \
   voff=-8.295e-02    dvt0=3.0000e+01    dvt1=1.5280e+00 \
   dvt2=2.5290e-02    keta=3.5850e-02 \
 pscbe1=1.0000e+30  pscbe2=1.0000e-06 \
 alpha0=7.7410e-09  alpha1=3.9830e-01   beta0=2.0700e+01 \
  dvt0w=-5.000e+00   dvt1w=2.5780e+06   dvt2w=5.1050e-02 \
     ua=4.7080e-10      ub=1.4700e-18      uc=-4.342e-11 \
u0=6.1370e+02+(6.1370e+02)*dumat \
   dsub=5.0000e-01    eta0=3.7950e-02    etab=-7.653e-04 \
nfactor=8.5730e-01 \
     em=4.1000e+07    pclm=2.1250e-01 \
  drout=5.0000e-01 \
     a0=2.0640e+00      a1=0.0000e+00      a2=1.0000e+00 \
   pvag=0.0000e+00    vsat=1.0780e+05     ags=1.0790e-01      b0=-1.493e-07      b1=0.0000e+00 \
  delta=1.0000e-02 pdiblcb=5.1860e-01 \
pdiblc1=1.0000e-04 pdiblc2=5.4580e-04 \
     w0=1.6170e-07 \
    dlc=1.0000e-07 \
    dwc=1.6230e-07     dwb=0.0000e+00     dwg=0.0000e+00 \
     ll=0.000e+00      lw=0.000e+00     lwl=0.000e+00 \
    lln=1.000e+00     lwn=1.000e+00      wl=0.0000e+00 \
     ww=-5.117e-14     wwl=-5.704e-21     wln=1.0000e+00 \
     wr=1.0000e+00     wwn=1.0000e+00 \
     at=3.3000e+04     ute=-1.760e+00 \
    kt1=-4.502e-01     kt2=2.2000e-02    kt1l=0.0000e+00 \
    ua1=0.0000e+00     ub1=0.0000e+00     uc1=0.0000e+00 \
    prt=0.0000e+00 \
   cgso=1.0800e-10    cgdo=1.0800e-10    cgbo=1.0000e-10 \
   cgdl=2.0000e-10    cgsl=2.0000e-10  ckappa=6.0000e-01 \
     cf=0.0000e+00     elm=5.0000e+00 \
  xpart=1.0000e+00     clc=1.0000e-15     cle=6.0000e-01 \
   noff=1.0000e+00  voffcv=0.0000e+00 \
   rdsw=1.3900e+03 \
   cdsc=0.0000e+00   cdscb=-1.500e-03   cdscd=0.0000e+00 \
   prwb=-6.740e-02    prwg=0.0000e+00     cit=0.0000e+00 \
tox=1.4000e-08 \
  ngate=0.0000e+00 \
    nlx=2.2830e-07 \
     xl=-6.000e-08      xw=5.0000e-08 \
     af=1.3580e+00      kf=3.4460e-26      ef=1.0000e+00 \
   noia=1.7020e+20    noib=5.4630e+05    noic=-1.400e-11 \
     rd=0.0000e+00      rs=0.0000e+00     rsh=5.5000e+01 \
   minr=1.000e-03 \
    rdc=0.0000e+00     rsc=0.0000e+00 lint=1.2250e-07 \
wint=1.6230e-07   ldif=0.000e+00    hdif=6.0000e-07 \
     xj=3.0000e-07      js=5.1000e-07 \
      n=1.0000e+00 \
  dskip=no          tlev=0           tlevc=0         \
    jsw=6.0000e-13 \
     cj=8.2700e-04    cjsw=2.2000e-10 \
     fc=0.0000e+00    fcsw=0.000e+00 \
     mj=3.4000e-01    mjsw=2.3000e-01 \
     pb=6.9000e-01    pbsw=6.9000e-01     xti=2.0260e+00
ends modnm

// ----------------------------------------------------------------------

// ----------------------------------------------------------------------
// Owner: austriamicrosystems
// HIT-Kit: Digital
// ************************ SIMULATION PARAMETERS ************************
//  ----------------------------------------------------------------------
//  format    : Spectre (Spectre Direct)
//  model     : MOS BSIM3v3
//  process   : C35
//  revision  : 5.0;
//  extracted : B27167L1W5C45; 15-04-2007; bse (5866)
//  doc#      : Eng-182 REV_6
//  ----------------------------------------------------------------------
//                         WORST CASE POWER CONDITION
//
//  ----------------------------------------------------------------------
//
inline subckt modnl ( d g s b )
parameters w=1.0e-6 l=1.0e-6 nrd=0.0 nrs=0.0 ad=0.0 as=0.0 pd=0.0 ps=0.0 ng=1
+ ws= w
+ ls= l
+ shk=1
+ dvthmat=(mv_modnl)*(0.67e-08/sqrt(ls*ws*ng)) dumat=(mu_modnl)*(4.9e-9/sqrt(ls*ws*ng))
//
if (modnl==1)
modnl ( d g s b ) mosinsub w=ws l=ls nrd=8.0000e-07/ws nrs=8.0000e-07/ws ad=ad as=as pd=pd ps=ps m=ng
else
modnl ( d s ) resistor r=1e30
notvalid paramtest errorif=(modnl==0) \
message="
***************************************************
*
* nmosl is not valid in selected process option.
*
***************************************************"
model mosinsub bsim3v3 version=3.2400e+00  type=n  capmod=2.0000e+00 \
 mobmod=1.0000e+00  nqsmod=0.0000e+00  noimod=3.0000e+00 \
   vbox=1.000e+03      k1=5.4000e-01 \
     k2=0.0000e+00      k3=7.6040e+00     k3b=0.0000e+00 \
    nch=1.6340e+17 vth0=3.4200e-01+dvthmat \
   voff=-8.000e-02    dvt0=1.2570e+01    dvt1=8.1290e-01 \
   dvt2=2.2200e-15    keta=-2.800e-03 \
 pscbe1=1.0000e+30  pscbe2=1.0000e-06 \
 alpha0=1.9000e-06  alpha1=1.0000e+00   beta0=2.0000e+01 \
  dvt0w=0.0000e+00   dvt1w=1.6970e+06   dvt2w=2.5060e-01 \
     ua=1.0000e-12      ub=2.1880e-18      uc=7.2440e-11 \
u0=4.6840e+02+(4.6840e+02)*dumat \
   dsub=5.0000e-01    eta0=5.1580e-02    etab=-6.600e-02 \
nfactor=1.0000e+00 \
     em=4.1000e+07    pclm=1.2650e+00 \
  drout=5.0000e-01 \
     a0=1.7080e+00      a1=0.0000e+00      a2=1.0000e+00 \
   pvag=3.1500e-01    vsat=9.4190e+04     ags=3.1620e-01      b0=2.6240e-08      b1=0.0000e+00 \
  delta=1.0000e-03 pdiblcb=3.6000e-01 \
pdiblc1=1.2970e-01 pdiblc2=1.9500e-03 \
     w0=2.5000e-06 \
    dlc=3.0000e-08 \
    dwc=9.5120e-08     dwb=0.0000e+00     dwg=-7.686e-09 \
     ll=6.3200e-15      lw=0.0000e+00     lwl=0.0000e+00 \
    lln=1.0000e+00     lwn=1.0000e+00      wl=0.0000e+00 \
     ww=-2.855e-14     wwl=-4.365e-21     wln=1.0000e+00 \
     wr=1.0000e+00     wwn=1.0000e+00 \
     at=1.0000e+04     ute=-1.700e+00 \
    kt1=-3.400e-01     kt2=-4.840e-02    kt1l=0.0000e+00 \
    ua1=0.0000e+00     ub1=0.0000e+00     uc1=0.0000e+00 \
    prt=0.0000e+00 \
   cgso=1.2000e-11    cgdo=1.2000e-11    cgbo=1.0000e-10 \
   cgdl=3.0000e-10    cgsl=3.0000e-10  ckappa=1.7010e+00 \
     cf=0.0000e+00     elm=5.0000e+00 \
  xpart=1.0000e+00     clc=1.0000e-15     cle=6.0000e-01 \
\
   rdsw=4.4670e+02 \
   cdsc=1.0000e-09   cdscb=0.0000e+00   cdscd=0.0000e+00 \
   prwb=0.0000e+00    prwg=1.9050e-02     cit=0.0000e+00 \
tox=7.1000e-09 \
  ngate=0.0000e+00 \
    nlx=1.4300e-07 \
     xl=-1.780e-08      xw=2.0000e-08 \
     af=1.4940e+00      kf=6.9860e-26      ef=1.0000e+00 \
   noia=9.8640e+19    noib=1.7020e+05    noic=-2.723e-12 \
     rd=0.0000e+00      rs=0.0000e+00     rsh=6.5000e+01 \
   minr=1.000e-03 \
    rdc=0.0000e+00     rsc=0.0000e+00 lint=-6.902e-09 \
wint=9.5120e-08   ldif=0.000e+00    hdif=8.0000e-07 \
     xj=3.0000e-07      js=5.1000e-07 \
      n=1.0000e+00 \
  dskip=no          tlev=0           tlevc=0         \
    jsw=6.0000e-13 \
     cj=6.6400e-04    cjsw=2.0000e-10 \
     fc=0.0000e+00    fcsw=0.000e+00 \
     mj=3.4000e-01    mjsw=2.3000e-01 \
     pb=6.9000e-01    pbsw=6.9000e-01     xti=2.0300e+00
ends modnl

// ----------------------------------------------------------------------

// ----------------------------------------------------------------------
// Owner: austriamicrosystems
// HIT-Kit: Digital
// ************************ SIMULATION PARAMETERS ************************
//  ----------------------------------------------------------------------
//  format    : Spectre (Spectre Direct)
//  model     : MOS BSIM3v3
//  process   : C35
//  revision  : 5.0;
//  extracted : B27167L1W5C45; 15-04-2007; bse (5866)
//  doc#      : Eng-182 REV_6
//  ----------------------------------------------------------------------
//                         WORST CASE POWER CONDITION
//
//  ----------------------------------------------------------------------
//
inline subckt modnml ( d g s b )
parameters w=1.0e-6 l=1.0e-6 nrd=0.0 nrs=0.0 ad=0.0 as=0.0 pd=0.0 ps=0.0 ng=1
+ ws= w
+ ls= l
+ shk=1
+ dvthmat=(mv_modnml)*(0.95e-08/sqrt(ls*ws*ng)) dumat=(mu_modnml)*(3.5e-9/sqrt(ls*ws*ng))
//
if (modnml==1)
modnml ( d g s b ) mosinsub w=ws l=ls nrd=6.0000e-07/ws nrs=6.0000e-07/ws ad=ad as=as pd=pd ps=ps m=ng
else
modnml ( d s ) resistor r=1e30
notvalid paramtest errorif=(modnml==0) \
message="
***************************************************
*
* nmosml is not valid in selected process option.
*
***************************************************"
model mosinsub bsim3v3 version=3.2400e+00  type=n  capmod=2.0000e+00 \
 mobmod=1.0000e+00  nqsmod=0.0000e+00  noimod=3.0000e+00 \
   vbox=1.000e+03      k1=9.8000e-01 \
     k2=0.0000e+00      k3=-1.456e+00     k3b=-7.244e-01 \
    nch=1.1770e+17 vth0=4.7940e-01+dvthmat \
   voff=-8.684e-02    dvt0=1.6010e+01    dvt1=1.0610e+00 \
   dvt2=4.5970e-02    keta=1.9180e-02 \
 pscbe1=1.0000e+30  pscbe2=1.0000e-06 \
 alpha0=1.6220e-08  alpha1=1.3800e-01   beta0=2.1000e+01 \
  dvt0w=0.0000e+00   dvt1w=3.0990e+06   dvt2w=4.5170e-02 \
     ua=1.0000e-12      ub=2.2910e-18      uc=6.9180e-11 \
u0=5.5070e+02+(5.5070e+02)*dumat \
   dsub=5.0000e-01    eta0=5.1290e-02    etab=-5.126e-03 \
nfactor=9.6050e-01 \
     em=4.1000e+07    pclm=1.1380e+00 \
  drout=5.0000e-01 \
     a0=1.0460e+00      a1=0.0000e+00      a2=1.0000e+00 \
   pvag=5.0000e-02    vsat=8.4420e+04     ags=1.2000e-01      b0=0.0000e+00      b1=0.0000e+00 \
  delta=1.8640e-03 pdiblcb=9.7980e-01 \
pdiblc1=6.1030e-06 pdiblc2=7.2440e-04 \
     w0=3.3160e-08 \
    dlc=1.0000e-07 \
    dwc=1.1660e-07     dwb=5.8200e-09     dwg=-1.000e-09 \
     ll=-9.793e-15      lw=0.0000e+00     lwl=0.0000e+00 \
    lln=1.0000e+00     lwn=1.0000e+00      wl=0.0000e+00 \
     ww=-4.017e-14     wwl=-1.380e-21     wln=1.0000e+00 \
     wr=1.0000e+00     wwn=1.0000e+00 \
     at=4.3550e+04     ute=-1.720e+00 \
    kt1=-4.500e-01     kt2=-6.560e-02    kt1l=0.0000e+00 \
    ua1=2.7540e-10     ub1=0.0000e+00     uc1=0.0000e+00 \
    prt=2.0000e+02 \
   cgso=1.0000e-12    cgdo=1.0000e-12    cgbo=1.0000e-10 \
   cgdl=3.8100e-10    cgsl=3.8100e-10  ckappa=1.9040e+00 \
     cf=0.0000e+00     elm=5.0000e+00 \
  xpart=1.0000e+00     clc=1.0000e-15     cle=6.0000e-01 \
\
   rdsw=1.1940e+03 \
   cdsc=2.4000e-04   cdscb=-7.468e-04   cdscd=0.0000e+00 \
   prwb=5.2110e-02    prwg=-5.443e-02     cit=0.0000e+00 \
tox=1.4000e-08 \
  ngate=1.0000e+00 \
    nlx=2.3690e-07 \
     xl=-1.208e-08      xw=2.0000e-09 \
     af=1.4000e+00      kf=3.7700e-26      ef=1.0000e+00 \
   noia=1.5360e+20    noib=3.5840e+05    noic=-1.304e-11 \
     rd=0.0000e+00      rs=0.0000e+00     rsh=6.5000e+01 \
   minr=1.000e-03 \
    rdc=0.0000e+00     rsc=0.0000e+00 lint=1.1900e-07 \
wint=1.1660e-07   ldif=0.000e+00    hdif=6.0000e-07 \
     xj=3.0000e-07      js=5.1000e-07 \
      n=1.0000e+00 \
  dskip=no          tlev=0           tlevc=0         \
    jsw=6.0000e-13 \
     cj=6.6600e-04    cjsw=2.0000e-10 \
     fc=0.0000e+00    fcsw=0.000e+00 \
     mj=3.4000e-01    mjsw=2.3000e-01 \
     pb=6.9000e-01    pbsw=6.9000e-01     xti=2.0300e+00
ends modnml

// ----------------------------------------------------------------------
// ----------------------------------------------------------------------
// Owner: austriamicrosystems
// HIT-Kit: Digital
// ************************ SIMULATION PARAMETERS ************************
//  ----------------------------------------------------------------------
//  format    : Spectre (Spectre Direct)
//  model     : MOS BSIM3v3
//  process   : C35
//  revision  : 4.1;
//  extracted : C64685 ; 2002-12; ese(5487)
//  doc#      : ENG-182 REV_6
//  ----------------------------------------------------------------------
//                         WORST CASE POWER CONDITION
//
//  ----------------------------------------------------------------------
//
inline subckt modpm ( d g s b )
parameters w=1.0e-6 l=1.0e-6 nrd=0.0 nrs=0.0 ad=0.0 as=0.0 pd=0.0 ps=0.0 ng=1
+ ws= w
+ ls= l
+ shk=1
+ dvthmat=(mv_modpm)*(1.5e-08/sqrt(ls*ws*ng)) dumat=(mu_modpm)*(7.1e-9/sqrt(ls*ws*ng))
//
if (modpm==1)
modpm ( d g s b ) mosinsub w=ws l=ls nrd=nrd nrs=nrs ad=ad as=as pd=pd ps=ps m=ng
else
modpm ( d s ) resistor r=1e30
notvalid paramtest errorif=(modpm==0) \
message="
***************************************************
*
* pmosm is not valid in selected process option.
*
***************************************************"
model mosinsub bsim3v3 version=3.2400e+00  type=p  capmod=2.0000e+00 \
 mobmod=1.0000e+00  nqsmod=0.0000e+00  noimod=3 \
   vbox=1.000e+03      k1=4.9104e-01 \
     k2=4.6442e-02      k3=8.3170e+00     k3b=-1.479e+00 \
    nch=7.4830e+16 vth0=-8.510e-01+dvthmat \
   voff=-1.148e-01    dvt0=5.3990e-01    dvt1=4.1120e-01 \
   dvt2=-9.479e-02    keta=3.0100e-02 \
 pscbe1=1.0000e+30  pscbe2=1.0000e-06 \
 alpha0=2.7100e-07  alpha1=1.9100e+00   beta0=3.4770e+01 \
  dvt0w=8.0990e-01   dvt1w=1.4800e+05   dvt2w=4.4040e-02 \
     ua=1.8000e-12      ub=2.2180e-18      uc=-7.278e-11 \
u0=1.5130e+02+(1.5130e+02)*dumat \
   dsub=5.0000e-01    eta0=9.7360e-02    etab=-2.948e-02 \
nfactor=7.0460e-01 \
     em=4.1000e+07    pclm=4.3950e+00 \
  drout=5.0000e-01 \
     a0=1.3860e+00      a1=0.0000e+00      a2=1.0000e+00 \
   pvag=0.0000e+00    vsat=1.4360e+05     ags=1.3640e-01      b0=1.9910e-08      b1=0.0000e+00 \
  delta=1.0000e-02 pdiblcb=1.0000e+00 \
pdiblc1=2.0370e-02 pdiblc2=1.0000e-20 \
     w0=1.0000e-10 \
    dlc=2.5000e-08 \
    dwc=6.2030e-08     dwb=0.0000e+00     dwg=0.0000e+00 \
     ll=0.000e+00      lw=0.000e+00     lwl=0.000e+00 \
    lln=1.000e+00     lwn=1.000e+00      wl=0.0000e+00 \
     ww=-9.750e-16     wwl=-1.787e-21     wln=1.0000e+00 \
     wr=1.0000e+00     wwn=1.0400e+00 \
     at=3.3000e+04     ute=-1.300e+00 \
    kt1=-6.003e-01     kt2=2.2000e-02    kt1l=0.0000e+00 \
    ua1=0.0000e+00     ub1=0.0000e+00     uc1=0.0000e+00 \
    prt=0.0000e+00 \
   cgso=9.1000e-11    cgdo=9.1000e-11    cgbo=1.0000e-10 \
   cgdl=5.2000e-11    cgsl=5.2000e-11  ckappa=6.0000e-01 \
     cf=0.0000e+00     elm=5.0000e+00 \
  xpart=1.0000e+00     clc=1.0000e-15     cle=6.0000e-01 \
   noff=1.0000e+00  voffcv=0.0000e+00 \
   rdsw=1.6230e+03 \
   cdsc=1.2140e-03   cdscb=2.9450e-04   cdscd=0.0000e+00 \
   prwb=-4.521e-01    prwg=0.0000e+00     cit=5.2590e-05 \
tox=1.4000e-08 \
  ngate=0.0000e+00 \
    nlx=2.2310e-07 \
     xl=-5.000e-08      xw=1.0000e-07 \
     af=1.5640e+00      kf=4.8520e-26      ef=1.0000e+00 \
   noia=1.8720e+18    noib=3.4540e+04    noic=1.2460e-12 \
     rd=0.0000e+00      rs=0.0000e+00     rsh=1.0080e+02 \
   minr=1.000e-03 \
    rdc=0.0000e+00     rsc=0.0000e+00 lint=-8.504e-08 \
wint=6.2030e-08   ldif=0.000e+00    hdif=6.0000e-07 \
     xj=3.0000e-07      js=2.8000e-07 \
      n=1.0000e+00 \
  dskip=no          tlev=0           tlevc=0         \
    jsw=3.7000e-13 \
     cj=1.1960e-03    cjsw=2.8100e-10 \
     fc=0.0000e+00    fcsw=0.000e+00 \
     mj=5.4000e-01    mjsw=4.6000e-01 \
     pb=1.0200e+00    pbsw=1.0200e+00     xti=1.9700e+00
ends modpm

// ----------------------------------------------------------------------

// ----------------------------------------------------------------------
// Owner: austriamicrosystems
// HIT-Kit: Digital
// ************************ SIMULATION PARAMETERS ************************
//  ----------------------------------------------------------------------
//  format    : Spectre (Spectre Direct)
//  model     : MOS BSIM3v3
//  process   : C35
//  revision  : 5.0;
//  extracted : B27167L1W5C45; 15-04-2007; bse (5866)
//  doc#      : Eng-182 REV_6
//  ----------------------------------------------------------------------
//                         WORST CASE POWER CONDITION
//
//  ----------------------------------------------------------------------
//
inline subckt modpml ( d g s b )
parameters w=1.0e-6 l=1.0e-6 nrd=0.0 nrs=0.0 ad=0.0 as=0.0 pd=0.0 ps=0.0 ng=1
+ ws= w
+ ls= l
+ shk=1
+ dvthmat=(mv_modpml)*(1.8e-08/sqrt(ls*ws*ng)) dumat=(mu_modpml)*(6.3e-9/sqrt(ls*ws*ng))
//
if (modpml==1)
modpml ( d g s b ) mosinsub w=ws l=ls nrd=6.0000e-07/ws nrs=6.0000e-07/ws ad=ad as=as pd=pd ps=ps m=ng
else
modpml ( d s ) resistor r=1e30
notvalid paramtest errorif=(modpml==0) \
message="
***************************************************
*
* pmosml is not valid in selected process option.
*
***************************************************"
model mosinsub bsim3v3 version=3.2400e+00  type=p  capmod=2.0000e+00 \
 mobmod=1.0000e+00  nqsmod=0.0000e+00  noimod=3.0000e+00 \
   vbox=1.000e+03      k1=6.7600e-01 \
     k2=-4.000e-03      k3=1.7420e+01     k3b=-1.738e+00 \
    nch=5.6580e+16 vth0=-5.880e-01+dvthmat \
   voff=-1.960e-01    dvt0=1.0000e+00    dvt1=4.2050e-01 \
   dvt2=-4.410e-02    keta=6.0000e-03 \
 pscbe1=1.0000e+30  pscbe2=1.0000e-06 \
 alpha0=1.3000e-07  alpha1=3.3320e-02   beta0=2.4820e+01 \
  dvt0w=5.7320e-01   dvt1w=2.8750e+05   dvt2w=1.6680e-01 \
     ua=3.3110e-09      ub=1.0000e-19      uc=-8.710e-11 \
u0=2.6590e+02+(2.6590e+02)*dumat \
   dsub=5.0000e-01    eta0=1.2500e-01    etab=-3.726e-04 \
nfactor=1.0210e+00 \
     em=4.1000e+07    pclm=2.5000e+00 \
  drout=5.0000e-01 \
     a0=1.1720e+00      a1=-1.581e-01      a2=1.0000e+00 \
   pvag=0.0000e+00    vsat=1.5690e+05     ags=1.4450e-01      b0=6.1800e-08      b1=0.0000e+00 \
  delta=2.9180e-02 pdiblcb=8.4520e-01 \
pdiblc1=1.1270e-02 pdiblc2=1.2500e-03 \
     w0=1.3800e-06 \
    dlc=4.5000e-08 \
    dwc=1.2300e-07     dwb=5.5110e-09     dwg=-5.171e-09 \
     ll=0.0000e+00      lw=0.0000e+00     lwl=0.0000e+00 \
    lln=1.0000e+00     lwn=1.0000e+00      wl=0.0000e+00 \
     ww=-4.460e-14     wwl=0.0000e+00     wln=1.0000e+00 \
     wr=1.0000e+00     wwn=1.0000e+00 \
     at=3.0000e+03     ute=-1.628e+00 \
    kt1=-6.603e-01     kt2=-8.840e-02    kt1l=0.0000e+00 \
    ua1=-2.399e-09     ub1=0.0000e+00     uc1=0.0000e+00 \
    prt=0.0000e+00 \
   cgso=6.4000e-11    cgdo=6.4000e-11    cgbo=1.0000e-10 \
   cgdl=1.4000e-10    cgsl=1.4000e-10  ckappa=1.4370e+00 \
     cf=0.0000e+00     elm=5.0000e+00 \
  xpart=1.0000e+00     clc=1.0000e-15     cle=6.0000e-01 \
\
   rdsw=6.3530e+02 \
   cdsc=1.4540e-04   cdscb=-2.792e-05   cdscd=0.0000e+00 \
   prwb=-3.097e-01    prwg=0.0000e+00     cit=0.0000e+00 \
tox=1.4000e-08 \
  ngate=1.0000e+00 \
    nlx=2.9510e-07 \
     xl=-6.000e-08      xw=2.0800e-09 \
     af=1.4710e+00      kf=1.3230e-26      ef=1.0000e+00 \
   noia=1.1970e+19    noib=2.6610e+04    noic=6.7840e-13 \
     rd=0.0000e+00      rs=0.0000e+00     rsh=1.1500e+02 \
   minr=1.000e-03 \
    rdc=0.0000e+00     rsc=0.0000e+00 lint=-7.553e-08 \
wint=1.2300e-07   ldif=0.000e+00    hdif=6.0000e-07 \
     xj=3.0000e-07      js=2.8000e-07 \
      n=1.0000e+00 \
  dskip=no          tlev=0           tlevc=0         \
    jsw=3.7000e-13 \
     cj=1.0880e-03    cjsw=2.8000e-10 \
     fc=0.0000e+00    fcsw=0.000e+00 \
     mj=5.4000e-01    mjsw=4.6000e-01 \
     pb=1.0200e+00    pbsw=1.0200e+00     xti=1.9700e+00
ends modpml

// ----------------------------------------------------------------------
//----------------------------------------------------------------------
//************************* SIMULATION PARAMETERS ************************
// ----------------------------------------------------------------------
// format    : Spectre ( Spectre Direct )
// model     : DIODE
// process   : C35
// revision  : 4.0;
// extracted : B10866 ; 2002-12; ese(5487)
// doc#      : ENG-182 REV_6
// ----------------------------------------------------------------------
//                       WORST CASE POWER CONDITION
// ----------------------------------------------------------------------
// TERMINALS: A=anode=P-region C=cathode=N-region
// VARIABLES: M (mulitiplier), AREA [m^2], PERI [m].
// NOTE: The role of a protection DIODE is to conduct ESD current to VDD
// (or from VSS). This forward bias is NOT modelled, only leakage current
// and capacitance during normal operation. Any inductive load etc that
// will give forward bias, must be limited by other components to within
// Operating Conditions, otherwise parasitic bipolar action can occur.
//
// Parameters: area perim
//
inline subckt nd ( a c )
parameters area=1.0e-12 perimeter=1.0e-6
//
if (subdiode==1)
nd ( a c ) diodeinsub area=area perim=perimeter region=off
else
nd ( a c ) resistor r=1e30
notvalid paramtest errorif=(subdiode==0) \
message="
***************************************************
*
* subdiode is not valid in selected process option.
*
***************************************************"
model diodeinsub diode level=1 dskip=no \
     is=5.1000e-07     isw=6.0000e-13       n=1.0000e+00      ns=1.0000e+00 \
   minr=0.100e+00    imax=(1.000e+00/area) \
    cjo=8.2700e-04       m=3.4000e-01      vj=6.9000e-01      tt=0.000e+00 \
    xti=2.0260e+00 \
   cjsw=2.2000e-10    mjsw=2.3000e-01    vjsw=6.9000e-01      fc=0.000e+00 \
     af=1.000e+00      kf=0.000e+00
ends nd
// ----------------------------------------------------------------------
// Owner: austriamicrosystems
// HIT-Kit: Digital
// ************************ SIMULATION PARAMETERS ************************
//  ----------------------------------------------------------------------
//  format    : Spectre (Spectre Direct)
//  model     : MOS BSIM3v3
//  process   : C35
//  revision  : 4.1;
//  extracted : C64685 ; 2002-12; ese(5487)
//  doc#      : ENG-182 REV_6
//  ----------------------------------------------------------------------
//                         WORST CASE POWER CONDITION
//
//  ----------------------------------------------------------------------
//
inline subckt modp ( d g s b )
parameters w=1.0e-6 l=1.0e-6 nrd=0.0 nrs=0.0 ad=0.0 as=0.0 pd=0.0 ps=0.0 ng=1
+ ws= w
+ ls= l
+ shk=1
+ dvthmat=(mv_modp)*(1.03e-08/sqrt(ls*ws*ng)) dumat=(mu_modp)*(7.1e-9/sqrt(ls*ws*ng))
//
if (modp==1)
modp ( d g s b ) mosinsub w=ws l=ls nrd=nrd nrs=nrs ad=ad as=as pd=pd ps=ps m=ng
else
modp ( d s ) resistor r=1e30
notvalid paramtest errorif=(modp==0) \
message="
***************************************************
*
* pmos is not valid in selected process option.
*
***************************************************"
model mosinsub bsim3v3 version=3.2400e+00  type=p  capmod=2.0000e+00 \
 mobmod=1.0000e+00  nqsmod=0.0000e+00  noimod=3 \
   vbox=1.000e+03      k1=4.5027e-01 \
     k2=-4.451e-02      k3=1.1030e+01     k3b=-7.580e-01 \
    nch=7.0220e+16 vth0=-5.715e-01+dvthmat \
   voff=-1.170e-01    dvt0=1.6500e+00    dvt1=3.8680e-01 \
   dvt2=1.6590e-02    keta=-1.440e-02 \
 pscbe1=1.0000e+30  pscbe2=1.0000e-06 \
 alpha0=1.0000e-09  alpha1=1.5000e+00   beta0=3.2500e+01 \
  dvt0w=1.8790e-01   dvt1w=7.3350e+04   dvt2w=-6.312e-03 \
     ua=5.3940e-10      ub=1.0530e-18      uc=1.0000e-20 \
u0=1.5810e+02+(1.5810e+02)*dumat \
   dsub=5.0000e-01    eta0=2.4800e-01    etab=-3.917e-03 \
nfactor=1.2140e+00 \
     em=4.1000e+07    pclm=3.1840e+00 \
  drout=5.0000e-01 \
     a0=5.8500e-01      a1=0.0000e+00      a2=1.0000e+00 \
   pvag=0.0000e+00    vsat=1.1580e+05     ags=2.4680e-01      b0=8.8320e-08      b1=0.0000e+00 \
  delta=1.0000e-02 pdiblcb=1.0000e+00 \
pdiblc1=1.0000e-04 pdiblc2=1.0000e-20 \
     w0=1.0000e-10 \
    dlc=2.4500e-08 \
    dwc=3.4490e-08     dwb=0.0000e+00     dwg=0.0000e+00 \
     ll=0.000e+00      lw=0.000e+00     lwl=0.000e+00 \
    lln=1.000e+00     lwn=1.000e+00      wl=0.0000e+00 \
     ww=1.8940e-16     wwl=-1.981e-21     wln=1.0000e+00 \
     wr=1.0000e+00     wwn=1.0400e+00 \
     at=3.3000e+04     ute=-1.300e+00 \
    kt1=-5.403e-01     kt2=2.2000e-02    kt1l=0.0000e+00 \
    ua1=0.0000e+00     ub1=0.0000e+00     uc1=0.0000e+00 \
    prt=0.0000e+00 \
   cgso=8.6000e-11    cgdo=8.6000e-11    cgbo=1.0000e-10 \
   cgdl=9.5000e-11    cgsl=9.5000e-11  ckappa=6.0000e-01 \
     cf=0.0000e+00     elm=5.0000e+00 \
  xpart=1.0000e+00     clc=1.0000e-15     cle=6.0000e-01 \
   noff=1.0000e+00  voffcv=0.0000e+00 \
   rdsw=1.0330e+03 \
   cdsc=2.5890e-03   cdscb=2.9430e-04   cdscd=4.3700e-04 \
   prwb=-9.731e-02    prwg=1.4770e-01     cit=0.0000e+00 \
tox=7.1000e-09 \
  ngate=0.0000e+00 \
    nlx=1.7700e-07 \
     xl=-6.000e-08      xw=8.0000e-08 \
     af=1.4050e+00      kf=1.8270e-26      ef=1.0000e+00 \
   noia=7.0910e+18    noib=6.0740e+04    noic=3.7790e-13 \
     rd=0.0000e+00      rs=0.0000e+00     rsh=1.0000e+02 \
   minr=1.000e-03 \
    rdc=0.0000e+00     rsc=0.0000e+00 lint=-7.130e-08 \
wint=3.4490e-08   ldif=0.000e+00    hdif=8.0000e-07 \
     xj=3.0000e-07      js=2.8000e-07 \
      n=1.0000e+00 \
  dskip=no          tlev=0           tlevc=0         \
    jsw=3.7000e-13 \
     cj=1.1970e-03    cjsw=2.8100e-10 \
     fc=0.0000e+00    fcsw=0.000e+00 \
     mj=5.4000e-01    mjsw=4.6000e-01 \
     pb=1.0200e+00    pbsw=1.0200e+00     xti=1.9730e+00
ends modp

// ----------------------------------------------------------------------

// ----------------------------------------------------------------------
// Owner: austriamicrosystems
// HIT-Kit: Digital
// ************************ SIMULATION PARAMETERS ************************
//  ----------------------------------------------------------------------
//  format    : Spectre (Spectre Direct)
//  model     : MOS BSIM3v3
//  process   : C35
//  revision  : 5.0;
//  extracted : B27167L1W5C45; 15-04-2007; bse (5866)
//  doc#      : Eng-182 REV_6
//  ----------------------------------------------------------------------
//                         WORST CASE POWER CONDITION
//
//  ----------------------------------------------------------------------
//
inline subckt modpl ( d g s b )
parameters w=1.0e-6 l=1.0e-6 nrd=0.0 nrs=0.0 ad=0.0 as=0.0 pd=0.0 ps=0.0 ng=1
+ ws= w
+ ls= l
+ shk=1
+ dvthmat=(mv_modpl)*(1.24e-08/sqrt(ls*ws*ng)) dumat=(mu_modpl)*(5.7e-9/sqrt(ls*ws*ng))
//
if (modpl==1)
modpl ( d g s b ) mosinsub w=ws l=ls nrd=8.0000e-07/ws nrs=8.0000e-07/ws ad=ad as=as pd=pd ps=ps m=ng
else
modpl ( d s ) resistor r=1e30
notvalid paramtest errorif=(modpl==0) \
message="
***************************************************
*
* pmosl is not valid in selected process option.
*
***************************************************"
model mosinsub bsim3v3 version=3.2400e+00  type=p  capmod=2.0000e+00 \
 mobmod=1.0000e+00  nqsmod=0.0000e+00  noimod=3.0000e+00 \
   vbox=1.000e+03      k1=6.8800e-01 \
     k2=-7.790e-02      k3=5.2610e+01     k3b=7.2440e+00 \
    nch=6.2010e+16 vth0=-4.440e-01+dvthmat \
   voff=-2.280e-01    dvt0=1.0460e+00    dvt1=3.9190e-01 \
   dvt2=1.9100e-03    keta=-2.400e-03 \
 pscbe1=1.0000e+30  pscbe2=1.0000e-06 \
 alpha0=1.1750e-08  alpha1=1.0000e-03   beta0=1.9580e+01 \
  dvt0w=1.0000e+00   dvt1w=5.3000e+06   dvt2w=9.5620e-02 \
     ua=1.0000e-12      ub=1.9050e-18      uc=6.3100e-11 \
u0=1.6050e+02+(1.6050e+02)*dumat \
   dsub=5.0000e-01    eta0=1.9590e-01    etab=0.0000e+00 \
nfactor=1.5790e+00 \
     em=4.1000e+07    pclm=8.2410e-01 \
  drout=5.0000e-01 \
     a0=5.0000e-01      a1=0.0000e+00      a2=1.0000e+00 \
   pvag=0.0000e+00    vsat=9.8190e+04     ags=2.6300e-01      b0=6.0600e-08      b1=0.0000e+00 \
  delta=4.3330e-03 pdiblcb=9.6330e-01 \
pdiblc1=1.0000e-03 pdiblc2=1.3800e-03 \
     w0=1.9050e-06 \
    dlc=2.0000e-08 \
    dwc=7.2920e-08     dwb=1.6220e-08     dwg=0.0000e+00 \
     ll=0.0000e+00      lw=0.0000e+00     lwl=0.0000e+00 \
    lln=1.0000e+00     lwn=1.0000e+00      wl=0.0000e+00 \
     ww=-2.000e-14     wwl=0.0000e+00     wln=1.0000e+00 \
     wr=1.0000e+00     wwn=1.0400e+00 \
     at=3.3000e+04     ute=-1.280e+00 \
    kt1=-5.577e-01     kt2=-6.560e-02    kt1l=0.0000e+00 \
    ua1=0.0000e+00     ub1=0.0000e+00     uc1=0.0000e+00 \
    prt=0.0000e+00 \
   cgso=5.6000e-11    cgdo=5.6000e-11    cgbo=1.0000e-10 \
   cgdl=2.1000e-10    cgsl=2.1000e-10  ckappa=5.6400e-01 \
     cf=0.0000e+00     elm=5.0000e+00 \
  xpart=1.0000e+00     clc=1.0000e-15     cle=6.0000e-01 \
\
   rdsw=2.0890e+03 \
   cdsc=1.3750e-03   cdscb=4.4880e-04   cdscd=1.9130e-04 \
   prwb=3.8020e-02    prwg=-1.047e-01     cit=0.0000e+00 \
tox=7.1000e-09 \
  ngate=1.0000e+00 \
    nlx=1.6220e-07 \
     xl=-3.170e-08      xw=2.0060e-09 \
     af=1.4690e+00      kf=1.2960e-26      ef=1.0000e+00 \
   noia=2.9220e+19    noib=1.7730e+04    noic=4.5200e-13 \
     rd=0.0000e+00      rs=0.0000e+00     rsh=1.1500e+02 \
   minr=1.000e-03 \
    rdc=0.0000e+00     rsc=0.0000e+00 lint=-1.285e-08 \
wint=7.2920e-08   ldif=0.000e+00    hdif=8.0000e-07 \
     xj=3.0000e-07      js=2.8000e-07 \
      n=1.0000e+00 \
  dskip=no          tlev=0           tlevc=0         \
    jsw=3.7000e-13 \
     cj=1.0880e-03    cjsw=2.8000e-10 \
     fc=0.0000e+00    fcsw=0.000e+00 \
     mj=5.4000e-01    mjsw=4.6000e-01 \
     pb=1.0200e+00    pbsw=1.0200e+00     xti=1.9700e+00
ends modpl

// ----------------------------------------------------------------------
//----------------------------------------------------------------------
//************************* SIMULATION PARAMETERS ************************
// ----------------------------------------------------------------------
// format    : Spectre ( Spectre Direct )
// model     : DIODE
// process   : C35
// revision  : 4.1;
// extracted : C64685 ; 2002-12; ese(5487)
// doc#      : ENG-182 REV_6
// ----------------------------------------------------------------------
//                       WORST CASE POWER CONDITION
// ----------------------------------------------------------------------
// TERMINALS: A=anode=P-region C=cathode=N-region
// VARIABLES: M (mulitiplier), AREA [m^2], PERI [m].
// NOTE: The role of a protection DIODE is to conduct ESD current to VDD
// (or from VSS). This forward bias is NOT modelled, only leakage current
// and capacitance during normal operation. Any inductive load etc that
// will give forward bias, must be limited by other components to within
// Operating Conditions, otherwise parasitic bipolar action can occur.
//
// Parameters: area perim
//
inline subckt pd ( a c )
parameters area=1.0e-12 perimeter=1.0e-6
//
if (welldiode==1)
pd ( a c ) diodeinsub area=area perim=perimeter region=off
else
pd ( a c ) resistor r=1e30
notvalid paramtest errorif=(welldiode==0) \
message="
***************************************************
*
* welldiode is not valid in selected process option.
*
***************************************************"
model diodeinsub diode level=1 dskip=no \
     is=2.8000e-07     isw=3.7000e-13       n=1.0000e+00      ns=1.0000e+00 \
   minr=0.100e+00    imax=(1.000e+00/area) \
    cjo=1.1970e-03       m=5.4000e-01      vj=1.0200e+00      tt=0.000e+00 \
    xti=1.9730e+00 \
   cjsw=2.8100e-10    mjsw=4.6000e-01    vjsw=1.0200e+00      fc=0.000e+00 \
     af=1.000e+00      kf=0.000e+00
ends pd
// ----------------------------------------------------------------------
// Owner: austriamicrosystems
// HIT-Kit: Digital
// ************************ SIMULATION PARAMETERS ************************
//  ----------------------------------------------------------------------
//  format    : Spectre (Spectre Direct)
//  model     : MOS BSIM3v3
//  process   : C35
//  revision  : 4.1;
//  extracted : C35 B11004.L2; 2002-11; hhl(5481)
//  doc#      : Eng-182  REV_6.0
//  ----------------------------------------------------------------------
//                        WORST CASE POWER CONDITION
//  ----------------------------------------------------------------------
//  HV-TRANSISTOR
//  ----------------------------------------------------------------------
inline subckt modnmh ( d g s b )
// Parameters: w l nrd nrs ad as pd ps
parameters w=1.0e-6 l=1.0e-6 nrd=0.0 nrs=0.0 ad=0.0 as=0.0 pd=0.0 ps=0.0 mult=1
+ ws=w
+ ls=l
+ dvthmat=mv_modnmh*(1.03e-08/sqrt(ls*ws*mult)) dumat=mu_modnmh*(3.5e-9/sqrt(ls*ws*mult))
//
if (modnmh==1){
modnmh ( d1 g s b ) mosinsub w=ws l=ls nrd=0 nrs=6.0000e-07/ws ad=ad as=as pd=pd ps=ps
rd ( d1 d ) resistor r=(1.1600e+03*4.0000e-06/(ws)) tc1=6.2000e-03
}else
modnmh ( d s ) resistor r=1e30
notvalid paramtest errorif=(modnmh==0) \
message="
***************************************************
*
* nmosmh is not valid in selected process option.
*
***************************************************"
//
model mosinsub bsim3v3 version=3.1 type=n  capmod=2.0000e+00 \
 mobmod=1.0000e+00  nqsmod=0.0000e+00  noimod=3 \
   vbox=1.000e+03      k1=7.1692e-01 \
     k2=6.6815e-02      k3=-2.439e+00     k3b=4.0770e-01 \
    nch=1.7730e+17 vth0=5.1490e-01+dvthmat \
   voff=-4.948e-02    dvt0=4.9850e+01    dvt1=1.6830e+00 \
   dvt2=4.1260e-02    keta=-7.397e-02 \
 pscbe1=4.0000e+10  pscbe2=1.0000e-10 \
 alpha0=0.0000e+00   beta0=3.0000e+01 \
  dvt0w=0.0000e+00   dvt1w=0.0000e+00   dvt2w=0.0000e+00 \
     ua=1.0000e-12      ub=3.7680e-19      uc=6.3910e-12 \
u0=4.9230e+02+(4.9230e+02)*dumat \
   dsub=5.0000e-01    eta0=1.6160e-03    etab=-1.373e-02 \
nfactor=3.4550e-01 \
     em=4.1000e+07    pclm=1.0550e-01 \
  drout=5.0000e-01 \
     a0=2.1900e-01      a1=0.0000e+00      a2=1.0000e+00 \
   pvag=0.0000e+00    vsat=5.1290e+04     ags=9.4480e-02      b0=-3.629e-08      b1=0.0000e+00 \
  delta=3.3700e-03 pdiblcb=3.8720e-01 \
pdiblc1=1.0000e-10 pdiblc2=1.0000e-10 \
     w0=6.2890e-08 \
    dlc=8.9170e-08 \
    dwc=4.9380e-08     dwb=0.0000e+00     dwg=0.0000e+00 \
     ll=0.0000e+00      lw=0.0000e+00     lwl=0.0000e+00 \
    lln=1.0000e+00     lwn=1.0000e+00      wl=0.0000e+00 \
     ww=0.0000e+00     wwl=0.0000e+00     wln=1.0000e+00 \
    wwn=1.0000e+00 \
   tnom=2.7000e+01      at=3.3000e+04     ute=-1.760e+00 \
    kt1=-4.502e-01     kt2=2.2000e-02    kt1l=0.0000e+00 \
    ua1=0.0000e+00     ub1=0.0000e+00     uc1=0.0000e+00 \
    prt=0.0000e+00 \
   cgso=9.5000e-11    cgdo=9.5000e-11    cgbo=1.0000e-10 \
   cgdl=0.0000e+00    cgsl=0.0000e+00  ckappa=6.0000e-01 \
     cf=0.0000e+00     elm=5.0000e+00 \
  xpart=1.0000e+00     clc=1.0000e-15     cle=6.0000e-01 \
\
   rdsw=5.3040e+02 \
   cdsc=1.0000e-02   cdscb=0.0000e+00   cdscd=8.4480e-05 \
   prwb=0.0000e+00    prwg=0.0000e+00     cit=8.1220e-04 \
tox=1.4000e-08 \
  ngate=0.0000e+00 \
    nlx=1.5930e-07 \
     xl=-1.050e-06      xw=1.0000e-07 \
     af=1.3580e+00      kf=3.4460e-26      ef=1.0000e+00 \
   noia=1.7020e+20    noib=5.4630e+05    noic=-1.400e-11 \
     rd=0.0000e+00      rs=0.0000e+00     rsh=5.5000e+01 \
   minr=1.000e-03 \
    rdc=0.0000e+00     rsc=0.0000e+00 lint=8.9170e-08 \
wint=4.9380e-08   ldif=0.000e+00    hdif=6.0000e-07 \
     xj=3.0000e-07      js=5.1000e-07 \
      n=1.0000e+00 \
  dskip=no          tlev=0           tlevc=0         \
    jsw=6.0000e-13 \
     cj=6.0000e-05    cjsw=3.8250e-10 \
     fc=0.0000e+00    fcsw=0.000e+00 \
     mj=3.9000e-01    mjsw=2.7000e-01 \
     pb=5.3000e-01    pbsw=6.9000e-01     xti=2.0260e+00
ends modnmh
// ----------------------------------------------------------------------
// Owner: austriamicrosystems
// HIT-Kit: Digital
// ************************ SIMULATION PARAMETERS ************************
//  ----------------------------------------------------------------------
//  format    : Spectre (Spectre Direct)
//  model     : MOS BSIM3v3
//  process   : c35
//  revision  : 4.1;
//  extracted : Wafer B26654W01 2005/10/10 REVISION 4.0; wpc(5481)
//  doc#      : Eng-182  REV 6.0
//  ----------------------------------------------------------------------
//                        WORST CASE POWER CONDITION
//  ----------------------------------------------------------------------
//  HV-TRANSISTOR
//  ----------------------------------------------------------------------
inline subckt modnmhl ( d g s b )
// Parameters: w l nrd nrs ad as pd ps
parameters w=1.0e-6 l=1.0e-6 nrd=0.0 nrs=0.0 ad=0.0 as=0.0 pd=0.0 ps=0.0 mult=1
+ ws=w
+ ls=l
+ dvthmat=mv_modnmhl*(0.95e-08/sqrt(ls*ws*mult)) dumat=mu_modnmhl*(3.5e-9/sqrt(ls*ws*mult))
//
if (modnmhl==1){
modnmhl ( d1 g s b ) mosinsub w=ws l=ls nrd=0 nrs=8.0000e-07/ws ad=ad as=as pd=pd ps=ps
rd ( d1 d ) resistor r=(1.0810e+03*4.0000e-06/(ws+(0.0000e+00))) tc1=6.2000e-03
}else
modnmhl ( d s ) resistor r=1e30
notvalid paramtest errorif=(modnmhl==0) \
message="
***************************************************
*
* nmosmhl is not valid in selected process option.
*
***************************************************"
//
model mosinsub bsim3v3 version=3.1 type=n  capmod=2.0000e+00 \
 mobmod=1.0000e+00  nqsmod=0.0000e+00  noimod=3 \
   vbox=1.000e+03      k1=6.8798e-01 \
     k2=3.6404e-02      k3=0.0000e+00     k3b=0.0000e+00 \
    nch=1.1720e+17 vth0=3.9500e-01+dvthmat \
   voff=-5.565e-02    dvt0=0.0000e+00    dvt1=1.6830e+00 \
   dvt2=4.1260e-02    keta=-8.210e-02 \
 pscbe1=4.0000e+10  pscbe2=1.0000e-10 \
 alpha0=0.0000e+00   beta0=3.0000e+01 \
  dvt0w=0.0000e+00   dvt1w=0.0000e+00   dvt2w=0.0000e+00 \
     ua=2.2380e-10      ub=0.0000e+00      uc=-1.429e-11 \
u0=5.7430e+02+(5.7430e+02)*dumat \
   dsub=5.0000e-01    eta0=1.6160e-03    etab=-1.373e-02 \
nfactor=8.5500e-01 \
     em=4.1000e+07    pclm=1.0550e-01 \
  drout=5.0000e-01 \
     a0=4.7540e-02      a1=0.0000e+00      a2=1.0000e+00 \
   pvag=0.0000e+00    vsat=5.2060e+04     ags=-3.227e-01      b0=0.0000e+00      b1=0.0000e+00 \
  delta=1.5850e-02 pdiblcb=3.8720e-01 \
pdiblc1=1.0000e-10 pdiblc2=1.0000e-10 \
     w0=0.0000e+00 \
    dlc=0.0000e+00 \
    dwc=0.0000e+00     dwb=0.0000e+00     dwg=0.0000e+00 \
     ll=0.0000e+00      lw=0.0000e+00     lwl=0.0000e+00 \
    lln=1.0000e+00     lwn=1.0000e+00      wl=0.0000e+00 \
     ww=0.0000e+00     wwl=0.0000e+00     wln=1.0000e+00 \
    wwn=1.0000e+00 \
     at=3.3000e+04     ute=-1.720e+00 \
    kt1=-4.202e-01     kt2=2.2000e-02    kt1l=0.0000e+00 \
    ua1=0.0000e+00     ub1=0.0000e+00     uc1=0.0000e+00 \
    prt=0.0000e+00 \
   cgso=8.0000e-11    cgdo=8.0000e-11    cgbo=1.0000e-10 \
   cgdl=0.0000e+00    cgsl=0.0000e+00  ckappa=6.0000e-01 \
     cf=0.0000e+00     elm=5.0000e+00 \
  xpart=1.0000e+00     clc=1.0000e-15     cle=6.0000e-01 \
\
   rdsw=5.3040e+02 \
   cdsc=0.0000e+00   cdscb=0.0000e+00   cdscd=0.0000e+00 \
   prwb=0.0000e+00    prwg=0.0000e+00     cit=2.9310e-05 \
tox=1.4400e-08 \
  ngate=0.0000e+00 \
    nlx=1.5930e-07 \
     xl=-1.000e-07      xw=1.5000e-07 \
     af=1.4000e+00      kf=3.7700e-26      ef=1.0000e+00 \
   noia=1.5360e+20    noib=3.5840e+05    noic=-1.304e-11 \
     rd=0.0000e+00      rs=0.0000e+00     rsh=7.5000e+01 \
   minr=1.000e-03 \
    rdc=0.0000e+00     rsc=0.0000e+00 lint=6.0000e-07 \
wint=0.0000e+00   ldif=0.000e+00    hdif=8.0000e-07 \
     xj=3.0000e-07      js=5.1000e-07 \
      n=1.0000e+00 \
  dskip=no          tlev=0           tlevc=0         \
    jsw=6.0000e-13 \
     cj=6.2250e-04    cjsw=1.8750e-10 \
     fc=0.0000e+00    fcsw=0.000e+00 \
     mj=3.4000e-01    mjsw=2.3000e-01 \
     pb=6.9000e-01    pbsw=6.9000e-01     xti=2.0300e+00
ends modnmhl
// ----------------------------------------------------------------------
// Owner: austriamicrosystems
// HIT-Kit: Digital
// ************************ SIMULATION PARAMETERS ************************
//  ----------------------------------------------------------------------
//  format    : Spectre (Spectre Direct)
//  model     : MOS BSIM3v3
//  process   : C35
//  revision  : 4.1;
//  extracted : C35 B11004.L2; 2002-11; hhl(5481)
//  doc#      : Eng-182  REV_6.0
//  ----------------------------------------------------------------------
//                        WORST CASE POWER CONDITION
//  ----------------------------------------------------------------------
//  HV-TRANSISTOR
//  ----------------------------------------------------------------------
inline subckt modnh ( d g s b )
// Parameters: w l nrd nrs ad as pd ps
parameters w=1.0e-6 l=1.0e-6 nrd=0.0 nrs=0.0 ad=0.0 as=0.0 pd=0.0 ps=0.0 mult=1
+ ws=w
+ ls=l
+ dvthmat=mv_modnh*(0.67e-08/sqrt(ls*ws*mult)) dumat=mu_modnh*(4.9e-9/sqrt(ls*ws*mult))
//
if (modnh==1){
modnh ( d1 g s b ) mosinsub w=ws l=ls nrd=0 nrs=6.0000e-07/ws ad=ad as=as pd=pd ps=ps
rd ( d1 d ) resistor r=(9.9600e+02*4.0000e-06/(ws)) tc1=6.2000e-03
}else
modnh ( d s ) resistor r=1e30
notvalid paramtest errorif=(modnh==0) \
message="
***************************************************
*
* nmosh is not valid in selected process option.
*
***************************************************"
//
model mosinsub bsim3v3 version=3.1 type=n  capmod=2.0000e+00 \
 mobmod=1.0000e+00  nqsmod=0.0000e+00  noimod=3 \
   vbox=1.000e+03      k1=5.2324e-01 \
     k2=-6.845e-03      k3=-2.240e+00     k3b=6.9540e-01 \
    nch=1.7590e+17 vth0=3.3600e-01+dvthmat \
   voff=-5.090e-02    dvt0=4.9850e+01    dvt1=1.2960e+00 \
   dvt2=1.3110e-02    keta=-4.553e-02 \
 pscbe1=1.0000e+10  pscbe2=1.0240e-05 \
 alpha0=0.0000e+00   beta0=3.0000e+01 \
  dvt0w=0.0000e+00   dvt1w=0.0000e+00   dvt2w=0.0000e+00 \
     ua=1.0000e-30      ub=1.9490e-18      uc=1.2170e-10 \
u0=3.7570e+02+(3.7570e+02)*dumat \
   dsub=5.0000e-01    eta0=3.0750e-02    etab=-5.261e-02 \
nfactor=2.0340e-01 \
     em=4.1000e+07    pclm=2.9400e-01 \
  drout=5.0000e-01 \
     a0=1.8930e-01      a1=0.0000e+00      a2=1.0000e+00 \
   pvag=0.0000e+00    vsat=2.4020e+05     ags=1.2450e-01      b0=6.7900e-08      b1=0.0000e+00 \
  delta=1.7290e-02 pdiblcb=2.0670e-01 \
pdiblc1=3.0900e-02 pdiblc2=6.3750e-04 \
     w0=1.1450e-07 \
    dlc=6.0000e-07 \
    dwc=2.6050e-08     dwb=0.0000e+00     dwg=0.0000e+00 \
     ll=0.0000e+00      lw=0.0000e+00     lwl=0.0000e+00 \
    lln=1.0000e+00     lwn=1.0000e+00      wl=0.0000e+00 \
     ww=0.0000e+00     wwl=0.0000e+00     wln=1.0000e+00 \
    wwn=1.0000e+00 \
   tnom=2.7000e+01      at=3.3000e+04     ute=-1.800e+00 \
    kt1=-3.302e-01     kt2=2.2000e-02    kt1l=0.0000e+00 \
    ua1=0.0000e+00     ub1=0.0000e+00     uc1=0.0000e+00 \
    prt=0.0000e+00 \
   cgso=1.0500e-10    cgdo=1.0500e-10    cgbo=1.0000e-10 \
   cgdl=0.0000e+00    cgsl=0.0000e+00  ckappa=6.0000e-01 \
     cf=0.0000e+00     elm=5.0000e+00 \
  xpart=1.0000e+00     clc=1.0000e-15     cle=6.0000e-01 \
\
   rdsw=1.0920e+03 \
   cdsc=7.9440e-03   cdscb=0.0000e+00   cdscd=8.4480e-05 \
   prwb=0.0000e+00    prwg=0.0000e+00     cit=1.0000e-03 \
tox=7.1000e-09 \
  ngate=0.0000e+00 \
    nlx=1.1320e-07 \
     xl=0.0000e+00      xw=1.0000e-07 \
     af=1.3580e+00      kf=3.4460e-26      ef=1.0000e+00 \
   noia=1.7020e+20    noib=5.4630e+05    noic=-1.400e-11 \
     rd=0.0000e+00      rs=0.0000e+00     rsh=5.5000e+01 \
   minr=1.000e-03 \
    rdc=0.0000e+00     rsc=0.0000e+00 lint=6.0000e-07 \
wint=2.6050e-08   ldif=0.000e+00    hdif=6.0000e-07 \
     xj=3.0000e-07      js=5.1000e-07 \
      n=1.0000e+00 \
  dskip=no          tlev=0           tlevc=0         \
    jsw=6.0000e-13 \
     cj=6.0000e-05    cjsw=3.8250e-10 \
     fc=0.0000e+00    fcsw=0.000e+00 \
     mj=3.9000e-01    mjsw=2.7000e-01 \
     pb=5.3000e-01    pbsw=6.9000e-01     xti=2.0260e+00
ends modnh
// ----------------------------------------------------------------------
// Owner: austriamicrosystems
// HIT-Kit: Digital
// ************************ SIMULATION PARAMETERS ************************
//  ----------------------------------------------------------------------
//  format    : Spectre (Spectre Direct)
//  model     : MOS BSIM3v3
//  process   : c35
//  revision  : 4.0;
//  extracted : Wafer B26654W01 2005/10/05 REVISION 4.0; wpc(5481)
//  doc#      : Eng-182  REV 6.0
//  ----------------------------------------------------------------------
//                        WORST CASE POWER CONDITION
//  ----------------------------------------------------------------------
//  HV-TRANSISTOR
//  ----------------------------------------------------------------------
inline subckt modnhl ( d g s b )
// Parameters: w l nrd nrs ad as pd ps
parameters w=1.0e-6 l=1.0e-6 nrd=0.0 nrs=0.0 ad=0.0 as=0.0 pd=0.0 ps=0.0 mult=1
+ ws=w
+ ls=l
+ dvthmat=mv_modnhl*(0.67e-08/sqrt(ls*ws*mult)) dumat=mu_modnhl*(4.9e-9/sqrt(ls*ws*mult))
//
if (modnhl==1){
modnhl ( d1 g s b ) mosinsub w=ws l=ls nrd=0 nrs=8.0000e-07/ws ad=ad as=as pd=pd ps=ps
rd ( d1 d ) resistor r=(4.5000e+02*4.0000e-06/(ws+(0.0000e+00))) tc1=6.2000e-03
}else
modnhl ( d s ) resistor r=1e30
notvalid paramtest errorif=(modnhl==0) \
message="
***************************************************
*
* nmoshl is not valid in selected process option.
*
***************************************************"
//
model mosinsub bsim3v3 version=3.1 type=n  capmod=2.0000e+00 \
 mobmod=1.0000e+00  nqsmod=0.0000e+00  noimod=3 \
   vbox=1.000e+03      k1=4.1725e-01 \
     k2=-2.691e-03      k3=0.0000e+00     k3b=0.0000e+00 \
    nch=1.1860e+17 vth0=2.6560e-01+dvthmat \
   voff=-5.119e-02    dvt0=0.0000e+00    dvt1=1.2960e+00 \
   dvt2=1.3110e-02    keta=-3.955e-02 \
 pscbe1=1.0000e+10  pscbe2=1.0240e-05 \
 alpha0=0.0000e+00   beta0=3.0000e+01 \
  dvt0w=0.0000e+00   dvt1w=0.0000e+00   dvt2w=0.0000e+00 \
     ua=1.0000e-30      ub=1.9490e-18      uc=1.2170e-10 \
u0=3.4910e+02+(3.4910e+02)*dumat \
   dsub=5.0000e-01    eta0=0.0000e+00    etab=0.0000e+00 \
nfactor=1.1530e+00 \
     em=4.1000e+07    pclm=2.9400e-01 \
  drout=5.0000e-01 \
     a0=3.3100e-01      a1=0.0000e+00      a2=1.0000e+00 \
   pvag=0.0000e+00    vsat=2.4020e+06     ags=3.2310e-01      b0=0.0000e+00      b1=0.0000e+00 \
  delta=3.1850e-02 pdiblcb=2.0670e-04 \
pdiblc1=3.0900e-02 pdiblc2=6.3750e-04 \
     w0=1.1450e-07 \
    dlc=0.0000e+00 \
    dwc=0.0000e+00     dwb=0.0000e+00     dwg=0.0000e+00 \
     ll=0.0000e+00      lw=0.0000e+00     lwl=0.0000e+00 \
    lln=1.0000e+00     lwn=1.0000e+00      wl=0.0000e+00 \
     ww=0.0000e+00     wwl=0.0000e+00     wln=1.0000e+00 \
    wwn=1.0000e+00 \
     at=3.3000e+04     ute=-1.700e+00 \
    kt1=-3.001e-01     kt2=2.2000e-02    kt1l=0.0000e+00 \
    ua1=0.0000e+00     ub1=0.0000e+00     uc1=0.0000e+00 \
    prt=0.0000e+00 \
   cgso=1.0500e-10    cgdo=1.0500e-10    cgbo=1.0000e-10 \
   cgdl=0.0000e+00    cgsl=0.0000e+00  ckappa=6.0000e-01 \
     cf=0.0000e+00     elm=5.0000e+00 \
  xpart=1.0000e+00     clc=1.0000e-15     cle=6.0000e-01 \
\
   rdsw=1.0920e+03 \
   cdsc=0.0000e+00   cdscb=0.0000e+00   cdscd=0.0000e+00 \
   prwb=0.0000e+00    prwg=0.0000e+00     cit=-2.050e-04 \
tox=7.1000e-09 \
  ngate=0.0000e+00 \
    nlx=1.1320e-07 \
     xl=-9.000e-08      xw=1.5000e-07 \
     af=1.4000e+00      kf=3.7700e-26      ef=1.0000e+00 \
   noia=1.5360e+20    noib=3.5840e+05    noic=-1.304e-11 \
     rd=0.0000e+00      rs=0.0000e+00     rsh=7.5000e+01 \
   minr=1.000e-03 \
    rdc=0.0000e+00     rsc=0.0000e+00 lint=6.0000e-07 \
wint=0.0000e+00   ldif=0.000e+00    hdif=8.0000e-07 \
     xj=3.0000e-07      js=5.1000e-07 \
      n=1.0000e+00 \
  dskip=no          tlev=0           tlevc=0         \
    jsw=6.0000e-13 \
     cj=6.2250e-04    cjsw=1.8750e-10 \
     fc=0.0000e+00    fcsw=0.000e+00 \
     mj=3.4000e-01    mjsw=2.3000e-01 \
     pb=6.9000e-01    pbsw=6.9000e-01     xti=2.0300e+00
ends modnhl
// ----------------------------------------------------------------------
// Owner: austriamicrosystems
// HIT-Kit: Digital
// ************************ SIMULATION PARAMETERS ************************
//  ----------------------------------------------------------------------
//  format    : Spectre (Spectre Direct)
//  model     : MOS BSIM3v3
//  process   : c35
//  revision  : ;
//  extracted : B58737.W09PE6; 2008-06; kmo(5966)
//  doc#      : ENG-327 Rev.2.0
//  ----------------------------------------------------------------------
//                        WORST CASE POWER CONDITION
//  ----------------------------------------------------------------------
//  HV-TRANSISTOR
//  ----------------------------------------------------------------------
inline subckt modn30m ( d g s b )
// Parameters: w l nrd nrs ad as pd ps
parameters w=1.0e-6 l=1.0e-6 nrd=0.0 nrs=0.0 ad=0.0 as=0.0 pd=0.0 ps=0.0 mult=1 gv=(7.6860e-08/l + 9.1600e-01) dcdc=1
+ dvthmat=mv_modn30m*(0.56e-08/sqrt(l*w*mult)) dumat=mu_modn30m*(2.9e-9/sqrt(l*w*mult))
if (modn30m==1){
//
modn30m ( d1 g s1 b ) mosinsub w=w l=l nrd=0 nrs=8.0000e-07/w ad=0 as=as pd=0 ps=ps
rd ( d1 d ) resistor r=(7.3450e-01/(w+(1.6670e-06))) tc1=6.0000e-03
xj1 ( d gj d1 ) modn30mjfet1 w=w
xj2 ( d gj d1 ) modn30mjfet2 w=w
e1 ( d1 gj d1 s ) vcvs gain=gv min=-25 max=25
cgdx ( g d ) capacitor c=(2.8600e-10*w)
v1 ( s1 s ) vsource dc=0 type=dc
i1 ( d b ) bsource i=((6.1450e-10)/(l+(0.0000e+00))+(6.1590e-03))*i("v1:p")*(max((v(d,g)+(1.8290e-02)),1e-15))**(4.1480e+00)*exp((-1.4550e+01)/max((v(d,g)+(1.8290e-02)),1e-10))*(w+0.0000e+00)/w/(1+2.8000e+04*exp(7.7390e-03*i("v1:p")/(w+0.0000e+00)))
xdw ( b d1 ) modn30mnwd area=(1e-06*2.35*(w+1e-06*16)) perimeter=(4e-06*2.35+(w+1e-06*16))
}else
modn30m ( d s ) resistor r=1e30
notvalid paramtest errorif=(modn30m==0) \
message="
***************************************************
*
* nmos30m is not valid in selected process option.
*
***************************************************"
//
model mosinsub bsim3v3 version=3.1 type=n  capmod=2.0000e+00 \
 mobmod=1.0000e+00  nqsmod=0.0000e+00  noimod=3.0000e+00 \
   vbox=1.000e+03      k1=7.9410e-01 \
     k2=4.2977e-02      k3=2.3030e-01     k3b=-1.516e-02 \
    nch=1.7070e+17 vth0=6.0770e-01+dvthmat \
   voff=-6.529e-02    dvt0=1.1390e-03    dvt1=1.0310e-01 \
   dvt2=-1.601e-01    keta=-1.236e-02 \
 pscbe1=3.5770e+12  pscbe2=5.7730e-12 \
 alpha0=0.0000e+00   beta0=3.0000e+01 \
  dvt0w=3.0490e-01   dvt1w=2.3530e+05   dvt2w=-2.685e+00 \
     ua=5.6220e-12      ub=9.5730e-19      uc=7.1200e-13 \
u0=4.7000e+02+(4.7000e+02)*dumat \
   dsub=5.2500e+00    eta0=1.0000e-07    etab=-3.000e-01 \
nfactor=9.0620e-01 \
     em=4.1000e+07    pclm=2.8550e+00 \
  drout=5.0000e-01 \
     a0=8.2080e-01      a1=0.0000e+00      a2=1.0000e+00 \
   pvag=0.0000e+00    vsat=8.9380e+04     ags=1.8620e-02      b0=3.0590e-09      b1=2.6720e-02 \
  delta=3.7770e-05 pdiblcb=1.0000e-12 \
pdiblc1=5.1750e-04 pdiblc2=3.7770e-07 \
     w0=-4.630e-06 \
    dlc=-3.250e-07 \
    dwc=2.7390e-07     dwb=0.0000e+00     dwg=0.0000e+00 \
     ll=0.0000e+00      lw=0.0000e+00     lwl=0.0000e+00 \
    lln=1.0000e+00     lwn=1.0000e+00      wl=0.0000e+00 \
     ww=0.0000e+00     wwl=0.0000e+00     wln=1.0000e+00 \
    wwn=1.0000e+00 \
     at=3.3000e+04     ute=-1.710e+00 \
    kt1=-4.600e-01     kt2=2.2000e-02    kt1l=0.0000e+00 \
    ua1=0.0000e+00     ub1=0.0000e+00     uc1=0.0000e+00 \
    prt=0.0000e+00 \
   cgso=8.5680e-11    cgdo=1.0000e-15    cgbo=8.8000e-11 \
   cgdl=5.0000e-10    cgsl=4.8800e-10  ckappa=1.9890e+00 \
     cf=0.0000e+00     elm=5.0000e+00 \
  xpart=5.0000e-01     clc=1.0000e-15     cle=6.0000e-01 \
\
   rdsw=0.0000e+00 \
   cdsc=1.9360e-06   cdscb=1.0000e-12   cdscd=1.0740e-08 \
   prwb=0.0000e+00    prwg=0.0000e+00     cit=1.0740e-06 \
tox=1.4000e-08 \
  ngate=0.0000e+00 \
    nlx=2.6040e-07 \
     xl=0.0000e+00      xw=0.0000e+00 \
     af=1.9886e+00      kf=1.6086e-24      ef=1.0000e+00 \
   noia=2.5794e+19    noib=1.0199e+05    noic=-2.372e-12 \
     rd=0.0000e+00      rs=0.0000e+00     rsh=7.5000e+01 \
   minr=1.000e-03 \
    rdc=0.0000e+00     rsc=0.0000e+00 lint=-2.271e-07 \
wint=2.7390e-07   ldif=0.000e+00    hdif=8.0000e-07 \
     xj=9.0000e-07      js=3.5530e-07 \
      n=1.0000e+00 \
  dskip=no          tlev=0           tlevc=0         \
    jsw=1.7560e-12 \
     cj=6.3000e-04    cjsw=1.8750e-10 \
     fc=0.0000e+00    fcsw=0.000e+00 \
     mj=3.4000e-01    mjsw=2.3000e-01 \
     pb=6.9000e-01    pbsw=6.9000e-01     xti=2.0260e+00
ends modn30m
// HV-jfet 1
inline subckt modn30mjfet1 (d b s)
parameters w=1e-6
modn30mjfet1 (d b s) rnjfetinsub
model rnjfetinsub jfet type=n \
beta=5.9740e+00/(1+(2.8000e-03)*(temp-(2.7000e+01)))*(w+(1.6670e-06))/(1+(6.0000e-03)*(temp-27)) \
vto=-5.700e+00*(1+(2.8000e-03)*(temp-(2.7000e+01))) \
lambda=0.0000e+00 \
is=0.0000e+00  pb=5.0000e-01 \
cgs=0.0000e+00 rs=0.0000e+00 \
cgd=0.0000e+00 rd=0.0000e+00
ends modn30mjfet1
// HV-jfet 2
inline subckt  modn30mjfet2 (d b s)
parameters w=1e-6
modn30mjfet2 (d b s) rnjfetinsub
model rnjfetinsub jfet type=n \
beta=6.0680e+00/(1+(2.8000e-03)*(temp-(2.7000e+01)))*(w+(1.6670e-06))/(1+(6.0000e-03)*(temp-27)) \
vto=-7.957e+00*(1+(2.8000e-03)*(temp-(2.7000e+01))) \
lambda=0.0000e+00 \
is=0.0000e+00  pb=5.0000e-01 \
cgs=0.0000e+00 rs=0.0000e+00 \
cgd=0.0000e+00 rd=0.0000e+00
ends modn30mjfet2
//

inline subckt modn30mnwd ( a c )
parameters area=1.0e-12 perimeter=1.0e-6
modn30mnwd ( a c ) diodeinsub area=area perim=perimeter region=off
model diodeinsub diode level=1 dskip=no \
is=1.676e-06          isw=2.158e-11                n=1.000e+00 ns=1.000e+00 \
minr=0.100e+00   imax=(1.000e+00/area) \
cj0=8.798e-05        m=2.737e-01                  vj=5.300e-01 tt=0.000e+00 \
cjsw=6.611e-10       mjsw=2.122e-01             vjsw=5.300e-01 fc=0.000e+00\
af=1.000e+00     kf=0.000e+00            xti=1.366e+00
ends modn30mnwd
// ----------------------------------------------------------------------
// Owner: austriamicrosystems
// HIT-Kit: Digital
// ************************ SIMULATION PARAMETERS ************************
//  ----------------------------------------------------------------------
//  format    : Spectre (Spectre Direct)
//  model     : MOS BSIM3v3
//  process   : c35
//  revision  : ;
//  extracted : B58737.W09PE6; 2008-06; kmo(5966)
//  doc#      : ENG-327 Rev.2.0
//  ----------------------------------------------------------------------
//                        WORST CASE POWER CONDITION
//  ----------------------------------------------------------------------
//  HV-TRANSISTOR
//  ----------------------------------------------------------------------
inline subckt modn18t ( d g s b )
// Parameters: w l nrd nrs ad as pd ps
parameters w=1.0e-6 l=1.0e-6 nrd=0.0 nrs=0.0 ad=0.0 as=0.0 pd=0.0 ps=0.0 mult=1 gv=(2.8290e-07/l + 8.9230e-01) dcdc=1
+ dvthmat=mv_modn18t*(0.78e-08/sqrt(l*w*mult)) dumat=mu_modn18t*(6.9e-09/sqrt(l*w*mult))
if (modn18t==1){
//
modn18t ( d1 g s1 b ) mosinsub w=w l=l nrd=0 nrs=8.0000e-07/w ad=0 as=as pd=0 ps=ps
rd ( d1 d ) resistor r=(7.4650e-01/(w+(2.4730e-06))) tc1=5.0000e-03
xj1 ( d gj d1 ) modn18tjfet1 w=w
xj2 ( d gj d1 ) modn18tjfet2 w=w
e1 ( d1 gj d1 s ) vcvs gain=gv min=-25 max=25
cgdx ( g d ) capacitor c=(3.5200e-10*w)
v1 ( s1 s ) vsource dc=0 type=dc
i1 ( d b ) bsource i=((5.3850e-10)/(l+(0.0000e+00))+(4.8260e-03))*i("v1:p")*(max((v(d,g)+(2.9600e-02)),1e-15))**(3.8580e+00)*exp((-4.2900e+00)/max((v(d,g)+(2.9600e-02)),1e-10))*(w+0.0000e+00)/w/(1+3.3810e+04*exp(5.3330e-03*i("v1:p")/(w+0.0000e+00)))
xdw ( b d1 ) modn18tnwd area=(1e-06*2.35*(w+1e-06*16)) perimeter=(4e-06*2.35+(w+1e-06*16))
}else
modn18t ( d s ) resistor r=1e30
notvalid paramtest errorif=(modn18t==0) \
message="
***************************************************
*
* nmos18t is not valid in selected process option.
*
***************************************************"
//
model mosinsub bsim3v3 version=3.1 type=n  capmod=2.0000e+00 \
 mobmod=1.0000e+00  nqsmod=0.0000e+00  noimod=3.0000e+00 \
   vbox=1.000e+03      k1=5.0718e-01 \
     k2=-2.438e-03      k3=-2.570e+00     k3b=1.9850e+00 \
    nch=1.7690e+17 vth0=3.8760e-01+dvthmat \
   voff=-8.829e-02    dvt0=1.8190e-01    dvt1=1.0200e-01 \
   dvt2=-5.409e-02    keta=-3.582e-02 \
 pscbe1=3.5770e+12  pscbe2=5.7730e-12 \
 alpha0=0.0000e+00   beta0=3.0000e+01 \
  dvt0w=7.9230e-01   dvt1w=6.0330e+05   dvt2w=-2.792e+00 \
     ua=2.1750e-10      ub=4.8850e-19      uc=1.2070e-10 \
u0=4.1300e+02+(4.1300e+02)*dumat \
   dsub=5.2500e+00    eta0=1.0000e-07    etab=-3.000e-01 \
nfactor=8.6770e-01 \
     em=4.1000e+07    pclm=6.0510e+00 \
  drout=5.0000e-01 \
     a0=7.6440e-01      a1=0.0000e+00      a2=1.0000e+00 \
   pvag=0.0000e+00    vsat=5.5760e+04     ags=2.3440e-01      b0=4.4050e-09      b1=2.6720e-02 \
  delta=2.5490e-05 pdiblcb=1.0000e-12 \
pdiblc1=2.2650e+00 pdiblc2=1.0000e-09 \
     w0=-7.990e-01 \
    dlc=-5.050e-07 \
    dwc=1.6680e-07     dwb=0.0000e+00     dwg=0.0000e+00 \
     ll=0.0000e+00      lw=0.0000e+00     lwl=0.0000e+00 \
    lln=1.0000e+00     lwn=1.0000e+00      wl=0.0000e+00 \
     ww=0.0000e+00     wwl=0.0000e+00     wln=1.0000e+00 \
    wwn=1.0000e+00 \
     at=3.3000e+04     ute=-1.720e+00 \
    kt1=-3.210e-01     kt2=2.2000e-02    kt1l=0.0000e+00 \
    ua1=0.0000e+00     ub1=0.0000e+00     uc1=0.0000e+00 \
    prt=0.0000e+00 \
   cgso=9.4000e-11    cgdo=1.0000e-15    cgbo=8.8000e-11 \
   cgdl=4.4020e-10    cgsl=5.0000e-10  ckappa=6.2280e-01 \
     cf=0.0000e+00     elm=5.0000e+00 \
  xpart=5.0000e-01     clc=1.0000e-15     cle=6.0000e-01 \
\
   rdsw=0.0000e+00 \
   cdsc=5.0330e-20   cdscb=2.9060e-04   cdscd=7.3780e-10 \
   prwb=0.0000e+00    prwg=0.0000e+00     cit=7.3780e-08 \
tox=7.1000e-09 \
  ngate=0.0000e+00 \
    nlx=1.4630e-07 \
     xl=0.0000e+00      xw=0.0000e+00 \
     af=2.0045e+00      kf=8.5977e-25      ef=1.0000e+00 \
   noia=4.8618e+18    noib=2.9560e+04    noic=-2.148e-13 \
     rd=0.0000e+00      rs=0.0000e+00     rsh=7.5000e+01 \
   minr=1.000e-03 \
    rdc=0.0000e+00     rsc=0.0000e+00 lint=-3.414e-07 \
wint=1.6680e-07   ldif=0.000e+00    hdif=8.0000e-07 \
     xj=9.0000e-07      js=3.5530e-07 \
      n=1.0000e+00 \
  dskip=no          tlev=0           tlevc=0         \
    jsw=1.7560e-12 \
     cj=6.3000e-04    cjsw=1.8750e-10 \
     fc=0.0000e+00    fcsw=0.000e+00 \
     mj=3.4000e-01    mjsw=2.3000e-01 \
     pb=6.9000e-01    pbsw=6.9000e-01     xti=2.0260e+00
ends modn18t
// HV-jfet 1
inline subckt modn18tjfet1 (d b s)
parameters w=1e-6
modn18tjfet1 (d b s) rnjfetinsub
model rnjfetinsub jfet type=n \
beta=5.4280e+00/(1+(1.6000e-03)*(temp-(2.7000e+01)))*(w+(2.4730e-06))/(1+(5.0000e-03)*(temp-27)) \
vto=-7.402e+00*(1+(1.6000e-03)*(temp-(2.7000e+01))) \
lambda=0.0000e+00 \
is=0.0000e+00  pb=5.0000e-01 \
cgs=0.0000e+00 rs=0.0000e+00 \
cgd=0.0000e+00 rd=0.0000e+00
ends modn18tjfet1
// HV-jfet 2
inline subckt  modn18tjfet2 (d b s)
parameters w=1e-6
modn18tjfet2 (d b s) rnjfetinsub
model rnjfetinsub jfet type=n \
beta=2.6640e+00/(1+(1.6000e-03)*(temp-(2.7000e+01)))*(w+(2.4730e-06))/(1+(5.0000e-03)*(temp-27)) \
vto=-7.947e+00*(1+(1.6000e-03)*(temp-(2.7000e+01))) \
lambda=0.0000e+00 \
is=0.0000e+00  pb=5.0000e-01 \
cgs=0.0000e+00 rs=0.0000e+00 \
cgd=0.0000e+00 rd=0.0000e+00
ends modn18tjfet2
//

inline subckt modn18tnwd ( a c )
parameters area=1.0e-12 perimeter=1.0e-6
modn18tnwd ( a c ) diodeinsub area=area perim=perimeter region=off
model diodeinsub diode level=1 dskip=no \
is=2.159e-06          isw=3.227e-11                n=1.000e+00 ns=1.000e+00 \
minr=0.100e+00   imax=(1.000e+00/area) \
cj0=8.992e-05        m=2.671e-01                  vj=5.300e-01 tt=0.000e+00 \
cjsw=6.406e-10       mjsw=2.161e-01             vjsw=5.300e-01 fc=0.000e+00\
af=1.000e+00     kf=0.000e+00            xti=4.786e-01
ends modn18tnwd

// ----------------------------------------------------------------------
// Owner: austriamicrosystems
// HIT-Kit: Digital
// ************************ SIMULATION PARAMETERS ************************
//  ----------------------------------------------------------------------
//  format    : Spectre (Spectre Direct)
//  model     : MOS HiSIM_HV
//  process   : c35
//  revision  : REVISION 3.0 Wafer C50118W01 2013/12/12;
//  extracted : MCT;
//  doc#      : Eng-327 REV 5.0
//  ----------------------------------------------------------------------
//                        WORST CASE POWER CONDITION
//  ----------------------------------------------------------------------
//
// UNSYMMETRIC HV-TRANSISTOR WITH EXTENDED PARASITICS
// PARAMS: NRD NRS AD AS PD PS AW PW (SEE NETLIST FORMAT DOC.)
// NMOS: N-Well Diode
// PMOS: P-Well Diode + PSUB+Diode
//  ----------------------------------------------------------------------
inline subckt modpd30m ( d g s b psub )
// Parameters: w l nrd nrs ad as pd ps
parameters w=1.0e-6 l=1.0e-6 nrd=0.0 nrs=0.0 ad=0.0 as=0.0 pd=0.0 ps=0.0 mult=1 dtemp=0
+ isoVoltage=50
+ dvthmat=(mv_modpd30m)*(1.73e-08/sqrt(l*w*mult)) dumat=(mu_modpd30m)*(6.15e-09/sqrt(l*w*mult))
if (modpd30m==1){
modpd30m ( d g s b ) mosinsub w=w l=l nrd=0 nrs=8.0000e-07/w ad=0 as=as pd=0 ps=ps
xpd ( d b ) modpd30mpd area=w*3.7e-06 perimeter=3.7e-06*2*mult
xnwd ( psub b ) modpd30mnwd area=(w+1e-06*23.6)*(l+1e-06*8.25) perimeter=4*(l+1e-06*8.25)+(w+1e-06*23.6)
}else
modpd30m ( d s ) resistor r=1e30
notvalid paramtest errorif=(modpd30m==0) \
message="
***************************************************
*
* pmosd30m is not valid in selected process option.
*
***************************************************"
//
model mosinsub hisim_hv version=1.230e+00 type=p \
 corsrd=3.0000e+00  coovlp=1.0000e+00 coovlps=1.0000e+00 \
 coisub=0.0000e+00  coiigs=0.0000e+00  cogidl=0.0000e+00 \
 coisti=0.0000e+00  coadov=1.0000e+00   conqs=0.0000e+00 \
   corg=0.0000e+00 corbnet=0.0000e+00 coflick=1.0000e+00 \
cothrml=1.0000e+00   coign=0.0000e+00  coiprv=1 \
  codfm=0.0000e+00 coselfheat=1.0000e+00   cosym=0.0000e+00  \
cosubnode=0.0000e+00  cotemp=0.0000e+00 coldrift=1.0000e+00 \
coqovsm=1.0000e+00  shemax=5.0000e+02  copprv=1.0000e+00
***************************************************************************
*                             Extension to LDMOS                          *
***************************************************************************
+loverld=1.0000e-08   lover=4.9860e-08 ldrift1=1.0000e-06 \
ldrift2=1.0000e-06  novers=1.8290e+17   nover=2.0600e+17
***************************************************************************
*                                   Charges                               *
***************************************************************************
+     xl=0.0000e+00      xw=5.3321e-11     xld=0.0000e+00 \
  xldld=-3.000e-07     xwd=1.6634e-06    xwdc=0.0000e+00   xwdld=0.0000e+00 \
     ll=0.0000e+00     lld=0.0000e+00     lln=0.0000e+00      wl=0.0000e+00 \
    wld=0.0000e+00     wln=0.0000e+00      vfbc=-4.717e-01+dvthmat \
    vbi=1.1000e+00      tox=1.4000e-08    ddltmax=2.4843e+00 \
ddltslp=0.0000e+00 ddltict=1.0000e+01   kappa=3.9000e+00
***************************************************************************
*                          Threshold Voltage Shift                        *
***************************************************************************
+  parl2=1.0000e-08      sc1=1.2113e+01     sc2=5.0000e-02 \
    sc3=0.0000e+00     sc4=0.0000e+00  pthrou=0.0000e+00 \
     nsubp=1.0520e+17      lp=1.3447e-07     bs1=0.0000e+00 \
    bs2=9.0000e-01    scp1=1.5395e+00    scp2=1.0000e-01 \
   scp3=0.0000e+00   scp21=0.0000e+00   scp22=0.0000e+00 \
  npext=1.0000e+17   lpext=1.0000e-50
***************************************************************************
*                   Depletion Effect of the Gate Poly-Si                  *
***************************************************************************
+   pgd1=0.0000e+00    pgd2=1.0000e+00    pgd3=8.0000e-01 \
   pgd4=0.0000e+00
***************************************************************************
*                       Quantum Mechanical Effects                        *
***************************************************************************
+   qme1=0.0000e+00    qme2=1.0000e+00    qme3=0.0000e+00
***************************************************************************
*                            Mobility Model                               *
***************************************************************************
+muecb0=1.0000e+02*(1+dumat)     muecb1=7.5427e+01*(1+dumat) mueph0=3.0000e-01 \
mueph1=8.7775e+03*(1+dumat) muephl=1.1341e+00  mueplp=1.0000e+00 \
 muesr0=2.2790e+00      muesr1=8.6146e+15*(1+dumat) muesrl=-1.087e-01 \
 mueslp=1.0000e+00    ndep=1.0000e+00   ndepl=0.0000e+00 \
 ndeplp=1.0000e+00    ninv=5.0000e-01   ninvd=0.0000e+00 \
     bb=1.0000e+00     vmax=6.4148e+06 \
  vover=3.2667e+00 \
 voverp=2.0000e+00
***************************************************************************
*                        Channel Length Modulation                        *
***************************************************************************
+   clm1=5.0000e-01    clm2=4.0000e+00    clm3=1.0000e+00 \
   clm5=1.0000e+00    clm6=0.0000e+00
***************************************************************************
*                          Narrow Channel Effects                         *
***************************************************************************
+    wfc=0.0000e+00   wvth0=-2.159e-01     nsubc=4.3775e+16 \
 nsubcw=0.0000e+00 nsubcwp=1.0000e+00  nsubp0=0.0000e+00 \
 nsubwp=1.0000e+00  muephw=4.5673e+00  muepwp=1.0000e+00 \
 muesrw=7.8626e-02  mueswp=1.0000e+00  vthsti=0.0000e+00 \
  vdsti=0.0000e+00  scsti1=0.0000e+00  scsti2=0.0000e+00 \
   nsti=1.0000e+17    wsti=0.0000e+00   wstil=0.0000e+00 \
 wstilp=1.0000e+00   wstiw=0.0000e+00  wstiwp=1.0000e+00 \
    wl1=0.0000e+00    wl1p=1.0000e+00     wl2=-1.938e-01 \
   wl2p=1.0000e+00  muephs=-5.777e-01  muepsp=1.0000e+00 \
 vovers=-1.000e-01 voversp=0.0000e+00
***************************************************************************
*                          Source/Drain Diffusion                         *
***************************************************************************
+nsubpsti1=0.0000e+00 nsubpsti2=0.0000e+00 nsubpsti3=1.0000e+00 \
muesti1=0.0000e+00 muesti2=0.0000e+00 muesti3=1.0000e+00 \
  saref=1.0000e-06   sbref=1.0000e-06
***************************************************************************
*                         Temperature Dependencies                        *
***************************************************************************
+    eg0=1.1790e+00  bgtmp1=9.0255e-05  bgtmp2=-2.432e-07 \
 muetmp=1.2226e+00    tnom=2.7000e+01    vtmp=3.6866e-01 \
   egig=0.0000e+00 igtemp2=0.0000e+00 igtemp3=0.0000e+00 \
rdtemp1=3.4836e-04 rdtemp2=2.6548e-06 rdvdtemp1=-5.189e-04 \
rdvdtemp2=9.7855e-07
***************************************************************************
*                                Resistances                              *
***************************************************************************
    +rd=5.9271e-03      rs=0.0000e+00     rsh=0.0000e+00 \
   rshg=0.0000e+00    rbpb=5.0000e+01    rbpd=5.0000e+01 \
   rbps=5.0000e+01 \
 rdvg11=6.4018e+00  rdvg12=1.6108e+01     rdvd=1.2640e-02 \
   rdvb=7.4912e-02     rds=-7.748e-01    rdsp=1.0000e+00 \
  rdvdl=0.0000e+00   rdvds=-4.921e-01  rdvdsp=1.0000e+00 \
 rdov11=0.0000e+00  rdov12=1.0000e+00  rdov13=1.0000e+00 \
 rdslp1=0.0000e+00    rd20=0.0000e+00    rd21=1.0000e+00 \
   rd22=-1.312e-01   rd22d=0.0000e+00     rd23=3.7023e-01 \
  rd23l=5.6859e-01  rd23lp=1.0000e+00   rd23s=-1.675e+00 \
 rd23sp=1.0000e+00    rd24=0.0000e+00    rd25=0.0000e+00 \
  gbmin=1.0000e-12
***************************************************************************
*                                Capacitances                             *
***************************************************************************
+    xqy=0.0000e+00    xqy1=0.0000e+00    xqy2=2.0000e+00 \
vfbover=-1.000e+00   qovsm=2.0000e-01   ovslp=2.0000e-08 \
  ovmag=5.0000e+02    cgso=1.8370e-10    cgdo=3.3980e-10 \
   cgbo=1.1000e-10   tpoly=2.0000e-07
***************************************************************************
*                              Leakage Currents                           *
***************************************************************************
+   sub1=5.0000e-02   sub1l=2.5000e-03  sub1lp=1.0000e+00 \
   sub2=3.0048e+01   sub2l=2.0000e-06    svds=8.0000e-01 \
    slg=3.0000e-08    slgl=0.0000e+00   slglp=1.0000e+00 \
   svbs=5.0000e-01   svbsl=0.0000e+00  svbslp=1.0000e+00 \
   svgs=8.0000e-01   svgsl=0.0000e+00  svgslp=1.0000e+00 \
  svgsw=0.0000e+00  svgswp=1.0000e+00   ibpc1=0.0000e+00 \
  ibpc2=0.0000e+00  subld1=0.0000e+00  subld2=0.0000e+00 \
 gleak1=5.0000e+01  gleak2=1.0000e+07  gleak3=6.0000e-02 \
 gleak4=4.0000e+00  gleak5=7.5000e+03  gleak6=2.5000e-01 \
 gleak7=1.0000e-06   glkb1=5.0000e-16   glkb2=1.0000e+00 \
  glkb3=0.0000e+00  glksd1=1.0000e-15  glksd2=1.0000e-02 \
 glksd3=-1.000e-02 glpart1=5.0000e-01     fn1=0.0000e+00 \
    fn2=0.0000e+00     fn3=0.0000e+00    fvbs=0.0000e+00 \
  gidl1=2.0000e+00   gidl2=3.0000e+07   gidl3=9.0000e-01 \
  gidl4=9.0000e-01   gidl5=2.0000e-01
***************************************************************************
*                             S/B and D/B Diodes                          *
***************************************************************************
+    js0=3.0890e-07   js0sw=1.1310e-13      nj=1.0000e+00 \
   njsw=1.0000e+00     xti=3.8400e+00    xti2=3.8400e+00 \
   divx=0.0000e+00    cisb=0.0000e+00     cvb=0.0000e+00 \
  ctemp=0.0000e+00   cisbk=0.0000e+00    cvbk=0.0000e+00 \
     cj=1.1968e-03    cjsw=3.0800e-10   cjswg=3.5000e-10 \
     mj=5.4000e-01    mjsw=4.6000e-01   mjswg=4.6000e-01 \
     pb=1.0200e+00    pbsw=1.0200e+00   pbswg=1.0200e+00 \
 vdiffj=6.0000e-04
***************************************************************************
*                                   Noise                                 *
***************************************************************************
+  nftrp=3.2435e+07   nfalp=1.5485e-18     cit=0.0000e+00 \
  falph=1.0000e+00
***************************************************************************
*                           Non Quasi Static Model                        *
***************************************************************************
+   dly1=1.0000e-10    dly2=7.0000e-01    dly3=8.0000e-07 \
  dlyov=0.0000e+00
***************************************************************************
*                            Self heating Effect                          *
***************************************************************************
+   rth0=5.5684e-01    cth0=1.0000e-07   rth0w=-8.500e+00 \
 rth0wp=1.0000e+00  rth0nf=0.0000e+00
***************************************************************************
*                                   DFM                                   *
***************************************************************************
+ mphdfm=-3.000e-01
***************************************************************************
*                         Additional Node                                 *
***************************************************************************
+ pzadd0=5.0000e-03  vzadd0=1.0000e-02 \
 rdict1=1.0000e+00  rdict2=0.0000e+00  rdvdlp=1.0000e+00 \
 vbsmin=-1.050e+01  rdslp2=1.0000e+00
***************************************************************************
*                         Additional Node                                 *
***************************************************************************
+ rdvsub=3.0000e-01 rdvdsub=1.0000e+00  ddrift=1.0000e-06 \
 vbisub=7.0000e-01 nsubsub=1.0000e+15
ends modpd30m
//

inline subckt modpd30mpd ( a c )
parameters area=1.0e-12 perimeter=1.0e-6
modpd30mpd ( a c ) diodeinsub area=area perim=perimeter region=off
model diodeinsub diode level=1 dskip=no \
  is=6.1140e-07          isw=2.4910e-13 \
   n=1.0400e+00           ns=1.0400e+00 \
minr=0.100e+00          imax=(1.000e+00/area) \
 cj0=1.2340e-03           m=6.2660e-01 \
  vj=1.0200e+00           tt=0.000e+00 \
cjsw=2.8230e-10         mjsw=4.8760e-01 \
vjsw=1.0200e+00           fc=0.000e+00 \
  af=1.000e+00             kf=0.000e+00 \
 xti=2.7630e+00
ends modpd30mpd
//

inline subckt modpd30mnwd ( a c )
parameters area=1.0e-12 perimeter=1.0e-6
modpd30mnwd ( a c ) diodeinsub area=area perim=perimeter region=off
model diodeinsub diode level=1 dskip=no \
  is=7.101e-06          isw=5.386e-12 \
   n=1.000e+00      ns=1.000e+00 \
minr=0.100e+00    imax=(1.000e+00/area) \
 cj0=3.850e-04           m=2.982e-01 \
  vj=5.300e-01          vjsw=5.300e-01 \
  fc=0.000e+00        tt=0.000e+00 \
cjsw=0.000e+00       mjsw=4.401e-01 \
  af=1.000e+00     kf=0.000e+00 \
 xti=-3.138e+00
ends modpd30mnwd

// ----------------------------------------------------------------------
// Owner: austriamicrosystems
// HIT-Kit: Digital
// ************************ SIMULATION PARAMETERS ************************
//  ----------------------------------------------------------------------
//  format    : Spectre (Spectre Direct)
//  model     : MOS HiSIM_HV
//  process   : c35
//  revision  : REVISION 1.0 Wafer C50118W01 2013/12/12;
//  extracted : MCT;
//  doc#      : Eng-327 REV 5.0
//  ----------------------------------------------------------------------
//                        WORST CASE POWER CONDITION
//  ----------------------------------------------------------------------
//
// UNSYMMETRIC HV-TRANSISTOR WITH EXTENDED PARASITICS
// PARAMS: NRD NRS AD AS PD PS AW PW (SEE NETLIST FORMAT DOC.)
// NMOS: N-Well Diode
// PMOS: P-Well Diode + PSUB+Diode
//  ----------------------------------------------------------------------
inline subckt modp30m ( d g s b psub )
// Parameters: w l nrd nrs ad as pd ps
parameters w=1.0e-6 l=1.0e-6 nrd=0.0 nrs=0.0 ad=0.0 as=0.0 pd=0.0 ps=0.0 mult=1 dtemp=0
+ isoVoltage=50
+ dvthmat=(mv_modp30m)*(1.73e-08/sqrt(l*w*mult)) dumat=(mu_modp30m)*(6.15e-09/sqrt(l*w*mult))
if (modp30m==1){
modp30m ( d g s b ) mosinsub w=w l=l nrd=0 nrs=8.0000e-07/w ad=0 as=as pd=0 ps=ps
xpd ( d b ) modp30mpd area=w*3.7e-06 perimeter=3.7e-06*2*mult
xnwd ( psub b ) modp30mnwd area=(w+1e-06*23.6)*(l+1e-06*8.25) perimeter=4*(l+1e-06*8.25)+(w+1e-06*23.6)
}else
modp30m ( d s ) resistor r=1e30
notvalid paramtest errorif=(modp30m==0) \
message="
***************************************************
*
* pmosd30m is not valid in selected process option.
*
***************************************************"
//
model mosinsub hisim_hv version=1.230e+00 type=p \
 corsrd=3.0000e+00  coovlp=1.0000e+00 coovlps=1.0000e+00 \
 coisub=0.0000e+00  coiigs=0.0000e+00  cogidl=0.0000e+00 \
 coisti=0.0000e+00  coadov=1.0000e+00   conqs=0.0000e+00 \
   corg=0.0000e+00 corbnet=0.0000e+00 coflick=1.0000e+00 \
cothrml=1.0000e+00   coign=0.0000e+00  coiprv=1 \
  codfm=0.0000e+00 coselfheat=1.0000e+00   cosym=0.0000e+00  \
cosubnode=0.0000e+00  cotemp=0.0000e+00 coldrift=1.0000e+00 \
coqovsm=1.0000e+00  shemax=5.0000e+02  copprv=1.0000e+00
***************************************************************************
*                             Extension to LDMOS                          *
***************************************************************************
+loverld=1.0000e-08   lover=4.9860e-08 ldrift1=1.0000e-06 \
ldrift2=1.0000e-06  novers=1.8290e+17   nover=2.0600e+17
***************************************************************************
*                                   Charges                               *
***************************************************************************
+     xl=0.0000e+00      xw=5.3321e-11     xld=0.0000e+00 \
  xldld=-3.000e-07     xwd=1.6634e-06    xwdc=0.0000e+00   xwdld=0.0000e+00 \
     ll=0.0000e+00     lld=0.0000e+00     lln=0.0000e+00      wl=0.0000e+00 \
    wld=0.0000e+00     wln=0.0000e+00      vfbc=-4.717e-01+dvthmat \
    vbi=1.1000e+00      tox=1.4000e-08    ddltmax=2.4843e+00 \
ddltslp=0.0000e+00 ddltict=1.0000e+01   kappa=3.9000e+00
***************************************************************************
*                          Threshold Voltage Shift                        *
***************************************************************************
+  parl2=1.0000e-08      sc1=1.2113e+01     sc2=5.0000e-02 \
    sc3=0.0000e+00     sc4=0.0000e+00  pthrou=0.0000e+00 \
     nsubp=1.0520e+17      lp=1.3447e-07     bs1=0.0000e+00 \
    bs2=9.0000e-01    scp1=1.5395e+00    scp2=1.0000e-01 \
   scp3=0.0000e+00   scp21=0.0000e+00   scp22=0.0000e+00 \
  npext=1.0000e+17   lpext=1.0000e-50
***************************************************************************
*                   Depletion Effect of the Gate Poly-Si                  *
***************************************************************************
+   pgd1=0.0000e+00    pgd2=1.0000e+00    pgd3=8.0000e-01 \
   pgd4=0.0000e+00
***************************************************************************
*                       Quantum Mechanical Effects                        *
***************************************************************************
+   qme1=0.0000e+00    qme2=1.0000e+00    qme3=0.0000e+00
***************************************************************************
*                            Mobility Model                               *
***************************************************************************
+muecb0=1.0000e+02*(1+dumat)     muecb1=7.5427e+01*(1+dumat) mueph0=3.0000e-01 \
mueph1=8.7775e+03*(1+dumat) muephl=1.1341e+00  mueplp=1.0000e+00 \
 muesr0=2.2790e+00      muesr1=8.6146e+15*(1+dumat) muesrl=-1.087e-01 \
 mueslp=1.0000e+00    ndep=1.0000e+00   ndepl=0.0000e+00 \
 ndeplp=1.0000e+00    ninv=5.0000e-01   ninvd=0.0000e+00 \
     bb=1.0000e+00     vmax=6.4148e+06 \
  vover=3.2667e+00 \
 voverp=2.0000e+00
***************************************************************************
*                        Channel Length Modulation                        *
***************************************************************************
+   clm1=5.0000e-01    clm2=4.0000e+00    clm3=1.0000e+00 \
   clm5=1.0000e+00    clm6=0.0000e+00
***************************************************************************
*                          Narrow Channel Effects                         *
***************************************************************************
+    wfc=0.0000e+00   wvth0=-2.159e-01     nsubc=4.3775e+16 \
 nsubcw=0.0000e+00 nsubcwp=1.0000e+00  nsubp0=0.0000e+00 \
 nsubwp=1.0000e+00  muephw=4.5673e+00  muepwp=1.0000e+00 \
 muesrw=7.8626e-02  mueswp=1.0000e+00  vthsti=0.0000e+00 \
  vdsti=0.0000e+00  scsti1=0.0000e+00  scsti2=0.0000e+00 \
   nsti=1.0000e+17    wsti=0.0000e+00   wstil=0.0000e+00 \
 wstilp=1.0000e+00   wstiw=0.0000e+00  wstiwp=1.0000e+00 \
    wl1=0.0000e+00    wl1p=1.0000e+00     wl2=-1.938e-01 \
   wl2p=1.0000e+00  muephs=-5.777e-01  muepsp=1.0000e+00 \
 vovers=-1.000e-01 voversp=0.0000e+00
***************************************************************************
*                          Source/Drain Diffusion                         *
***************************************************************************
+nsubpsti1=0.0000e+00 nsubpsti2=0.0000e+00 nsubpsti3=1.0000e+00 \
muesti1=0.0000e+00 muesti2=0.0000e+00 muesti3=1.0000e+00 \
  saref=1.0000e-06   sbref=1.0000e-06
***************************************************************************
*                         Temperature Dependencies                        *
***************************************************************************
+    eg0=1.1790e+00  bgtmp1=9.0255e-05  bgtmp2=-2.432e-07 \
 muetmp=1.2226e+00    tnom=2.7000e+01    vtmp=3.6866e-01 \
   egig=0.0000e+00 igtemp2=0.0000e+00 igtemp3=0.0000e+00 \
rdtemp1=3.4836e-04 rdtemp2=2.6548e-06 rdvdtemp1=-5.189e-04 \
rdvdtemp2=9.7855e-07
***************************************************************************
*                                Resistances                              *
***************************************************************************
    +rd=5.9271e-03      rs=0.0000e+00     rsh=0.0000e+00 \
   rshg=0.0000e+00    rbpb=5.0000e+01    rbpd=5.0000e+01 \
   rbps=5.0000e+01 \
 rdvg11=6.4018e+00  rdvg12=1.6108e+01     rdvd=1.2640e-02 \
   rdvb=7.4912e-02     rds=-7.748e-01    rdsp=1.0000e+00 \
  rdvdl=0.0000e+00   rdvds=-4.921e-01  rdvdsp=1.0000e+00 \
 rdov11=0.0000e+00  rdov12=1.0000e+00  rdov13=1.0000e+00 \
 rdslp1=0.0000e+00    rd20=0.0000e+00    rd21=1.0000e+00 \
   rd22=-1.312e-01   rd22d=0.0000e+00     rd23=3.7023e-01 \
  rd23l=5.6859e-01  rd23lp=1.0000e+00   rd23s=-1.675e+00 \
 rd23sp=1.0000e+00    rd24=0.0000e+00    rd25=0.0000e+00 \
  gbmin=1.0000e-12
***************************************************************************
*                                Capacitances                             *
***************************************************************************
+    xqy=0.0000e+00    xqy1=0.0000e+00    xqy2=2.0000e+00 \
vfbover=-1.000e+00   qovsm=2.0000e-01   ovslp=2.0000e-08 \
  ovmag=5.0000e+02    cgso=1.8370e-10    cgdo=3.3980e-10 \
   cgbo=1.1000e-10   tpoly=2.0000e-07
***************************************************************************
*                              Leakage Currents                           *
***************************************************************************
+   sub1=5.0000e-02   sub1l=2.5000e-03  sub1lp=1.0000e+00 \
   sub2=3.0048e+01   sub2l=2.0000e-06    svds=8.0000e-01 \
    slg=3.0000e-08    slgl=0.0000e+00   slglp=1.0000e+00 \
   svbs=5.0000e-01   svbsl=0.0000e+00  svbslp=1.0000e+00 \
   svgs=8.0000e-01   svgsl=0.0000e+00  svgslp=1.0000e+00 \
  svgsw=0.0000e+00  svgswp=1.0000e+00   ibpc1=0.0000e+00 \
  ibpc2=0.0000e+00  subld1=0.0000e+00  subld2=0.0000e+00 \
 gleak1=5.0000e+01  gleak2=1.0000e+07  gleak3=6.0000e-02 \
 gleak4=4.0000e+00  gleak5=7.5000e+03  gleak6=2.5000e-01 \
 gleak7=1.0000e-06   glkb1=5.0000e-16   glkb2=1.0000e+00 \
  glkb3=0.0000e+00  glksd1=1.0000e-15  glksd2=1.0000e-02 \
 glksd3=-1.000e-02 glpart1=5.0000e-01     fn1=0.0000e+00 \
    fn2=0.0000e+00     fn3=0.0000e+00    fvbs=0.0000e+00 \
  gidl1=2.0000e+00   gidl2=3.0000e+07   gidl3=9.0000e-01 \
  gidl4=9.0000e-01   gidl5=2.0000e-01
***************************************************************************
*                             S/B and D/B Diodes                          *
***************************************************************************
+    js0=3.0890e-07   js0sw=1.1310e-13      nj=1.0000e+00 \
   njsw=1.0000e+00     xti=3.8400e+00    xti2=3.8400e+00 \
   divx=0.0000e+00    cisb=0.0000e+00     cvb=0.0000e+00 \
  ctemp=0.0000e+00   cisbk=0.0000e+00    cvbk=0.0000e+00 \
     cj=1.1968e-03    cjsw=3.0800e-10   cjswg=3.5000e-10 \
     mj=5.4000e-01    mjsw=4.6000e-01   mjswg=4.6000e-01 \
     pb=1.0200e+00    pbsw=1.0200e+00   pbswg=1.0200e+00 \
 vdiffj=6.0000e-04
***************************************************************************
*                                   Noise                                 *
***************************************************************************
+  nftrp=3.2435e+07   nfalp=1.5485e-18     cit=0.0000e+00 \
  falph=1.0000e+00
***************************************************************************
*                           Non Quasi Static Model                        *
***************************************************************************
+   dly1=1.0000e-10    dly2=7.0000e-01    dly3=8.0000e-07 \
  dlyov=0.0000e+00
***************************************************************************
*                            Self heating Effect                          *
***************************************************************************
+   rth0=5.5684e-01    cth0=1.0000e-07   rth0w=-8.500e+00 \
 rth0wp=1.0000e+00  rth0nf=0.0000e+00
***************************************************************************
*                                   DFM                                   *
***************************************************************************
+ mphdfm=-3.000e-01
***************************************************************************
*                         Additional Node                                 *
***************************************************************************
+ pzadd0=5.0000e-03  vzadd0=1.0000e-02 \
 rdict1=1.0000e+00  rdict2=0.0000e+00  rdvdlp=1.0000e+00 \
 vbsmin=-1.050e+01  rdslp2=1.0000e+00
***************************************************************************
*                         Additional Node                                 *
***************************************************************************
+ rdvsub=3.0000e-01 rdvdsub=1.0000e+00  ddrift=1.0000e-06 \
 vbisub=7.0000e-01 nsubsub=1.0000e+15
ends modp30m
//

inline subckt modp30mpd ( a c )
parameters area=1.0e-12 perimeter=1.0e-6
modp30mpd ( a c ) diodeinsub area=area perim=perimeter region=off
model diodeinsub diode level=1 dskip=no \
  is=6.1140e-07          isw=2.4910e-13 \
   n=1.0400e+00           ns=1.0400e+00 \
minr=0.100e+00          imax=(1.000e+00/area) \
 cj0=1.2340e-03           m=6.2660e-01 \
  vj=1.0200e+00           tt=0.000e+00 \
cjsw=2.8230e-10         mjsw=4.8760e-01 \
vjsw=1.0200e+00           fc=0.000e+00 \
  af=1.000e+00             kf=0.000e+00 \
 xti=2.7630e+00
ends modp30mpd
//

inline subckt modp30mnwd ( a c )
parameters area=1.0e-12 perimeter=1.0e-6
modp30mnwd ( a c ) diodeinsub area=area perim=perimeter region=off
model diodeinsub diode level=1 dskip=no \
  is=7.101e-06          isw=5.386e-12 \
   n=1.000e+00      ns=1.000e+00 \
minr=0.100e+00    imax=(1.000e+00/area) \
 cj0=3.850e-04           m=2.982e-01 \
  vj=5.300e-01          vjsw=5.300e-01 \
  fc=0.000e+00        tt=0.000e+00 \
cjsw=0.000e+00       mjsw=4.401e-01 \
  af=1.000e+00     kf=0.000e+00 \
 xti=-3.138e+00
ends modp30mnwd

// ----------------------------------------------------------------------
// Owner: austriamicrosystems
// HIT-Kit: Digital
// ************************ SIMULATION PARAMETERS ************************
//  ----------------------------------------------------------------------
//  format    : Spectre (Spectre Direct)
//  model     : MOS BSIM3v3
//  process   : C35
//  revision  : 1.0;
//  extracted : C18069; 28.08.2011; bse (5866)
//  doc#      : Eng-?? REV_0
//  ----------------------------------------------------------------------
//                         WORST CASE POWER CONDITION
//
//  ----------------------------------------------------------------------
//
inline subckt nmosw_2n ( d g s b )
parameters w=1.0e-6 l=1.0e-6 nrd=0.0 nrs=0.0 ad=0.0 as=0.0 pd=0.0 ps=0.0 ng=1
+ ws= w
+ ls= l
+ shk=1
+ dvthmat=(mv_nmosw_2n)*(0.67e-08/sqrt(ls*ws*ng)) dumat=(mu_nmosw_2n)*(4.9e-9/sqrt(ls*ws*ng))
//
if (modn==1)
nmosw_2n ( d g s b ) mosinsub w=ws l=ls nrd=8.0000e-07/ws nrs=8.0000e-07/ws ad=ad as=as pd=pd ps=ps m=ng
else
nmosw_2n ( d s ) resistor r=1e30
notvalid paramtest errorif=(modn==0) \
message="
***************************************************
*
* nmos is not valid in selected process option.
*
***************************************************"
model mosinsub bsim3v3 version=3.2400e+00  type=n  capmod=3.0000e+00 \
 mobmod=1.0000e+00  nqsmod=0.0000e+00  noimod=3.0000e+00 \
   vbox=1.000e+03      k1=4.6580e-01 \
     k2=0.0000e+00      k3=3.0270e-02     k3b=-1.089e-02 \
    nch=1.9540e+17 vth0=3.5220e-01+dvthmat \
   voff=-7.600e-02    dvt0=2.1160e+01    dvt1=1.0640e+00 \
   dvt2=3.0590e-02    keta=-1.200e-02 \
 pscbe1=1.0000e+30  pscbe2=1.0000e-06 \
 alpha0=1.9040e-06  alpha1=2.5000e+00   beta0=2.0000e+01 \
  dvt0w=2.0000e+00   dvt1w=1.6970e+06   dvt2w=-1.556e-02 \
     ua=-3.981e-10      ub=2.6890e-18      uc=6.9180e-11 \
u0=4.2940e+02+(4.2940e+02)*dumat \
   dsub=5.0000e-01    eta0=1.4790e-02    etab=-5.280e-02 \
nfactor=2.6780e-01 \
     em=4.1000e+07    pclm=9.6570e-01 \
  drout=5.0000e-01 \
     a0=2.0840e+00      a1=0.0000e+00      a2=1.0000e+00 \
   pvag=1.3460e-01    vsat=1.0200e+05     ags=3.6080e-01      b0=5.0200e-08      b1=1.0060e-07 \
  delta=2.3500e-03 pdiblcb=3.2150e-01 \
pdiblc1=1.0800e-01 pdiblc2=1.6220e-03 \
     w0=-3.185e-07 \
    dlc=-1.588e-08 \
dwc=-3.263e-01*l+1.5050e-07    dwb=0.0000e+00     dwg=-9.302e-09 \
     ll=1.0680e-13      lw=0.0000e+00     lwl=0.0000e+00 \
    lln=1.0000e+00     lwn=1.0000e+00      wl=2.8610e-13 \
     ww=-1.130e-14     wwl=-9.411e-21     wln=1.0000e+00 \
     wr=1.0000e+00     wwn=1.0000e+00 \
     at=2.5000e+04     ute=-1.700e+00 \
    kt1=-3.100e-01     kt2=-1.720e-02    kt1l=0.0000e+00 \
    ua1=0.0000e+00     ub1=0.0000e+00     uc1=0.0000e+00 \
    prt=3.0000e+01 \
   cgso=1.0850e-12    cgdo=1.0850e-12    cgbo=1.4960e-08 \
   cgdl=2.5110e-10    cgsl=2.5110e-10  ckappa=2.6020e+00 \
     cf=0.0000e+00     elm=5.0000e+00 \
  xpart=1.0000e+00     clc=1.0000e-15     cle=6.0000e-01 \
\
   rdsw=1.1390e+03 \
   cdsc=0.0000e+00   cdscb=1.5000e-09   cdscd=0.0000e+00 \
   prwb=-5.000e-02    prwg=1.3340e-02     cit=8.0260e-04 \
tox=7.1650e-09 \
  ngate=1.0000e+00 \
    nlx=1.7000e-07 \
     xl=-3.796e-08      xw=0.0000e+00 \
     af=1.3760e+00      kf=3.3960e-26      ef=1.0000e+00 \
   noia=1.3990e+20    noib=2.7070e+05    noic=-4.680e-12 \
     rd=0.0000e+00      rs=0.0000e+00     rsh=6.5000e+01 \
   minr=1.000e-03 \
    rdc=0.0000e+00     rsc=0.0000e+00 lint=-3.098e-07 \
wint=-8.969e-07   ldif=0.000e+00    hdif=8.0000e-07 \
     xj=3.0000e-07      js=5.1000e-07 \
      n=1.0000e+00 \
  dskip=no          tlev=0           tlevc=0         \
    jsw=6.0000e-13 \
     cj=6.2250e-04    cjsw=1.8750e-10 \
     fc=0.0000e+00    fcsw=0.000e+00 \
     mj=3.4000e-01    mjsw=2.3000e-01 \
     pb=6.9000e-01    pbsw=6.9000e-01     xti=2.0300e+00
ends nmosw_2n

// ----------------------------------------------------------------------

// ----------------------------------------------------------------------
// Owner: austriamicrosystems
// HIT-Kit: Digital
// ************************ SIMULATION PARAMETERS ************************
//  ----------------------------------------------------------------------
//  format    : Spectre (Spectre Direct)
//  model     : MOS BSIM3v3
//  process   : C35
//  revision  : 1.0;
//  extracted : C18069; 28.08.2011; bse (5866)
//  doc#      : Eng-?? REV_0
//  ----------------------------------------------------------------------
//                         WORST CASE POWER CONDITION
//
//  ----------------------------------------------------------------------
//
inline subckt nmosw_3n ( d g s b )
parameters w=1.0e-6 l=1.0e-6 nrd=0.0 nrs=0.0 ad=0.0 as=0.0 pd=0.0 ps=0.0 ng=1
+ ws= w
+ ls= l
+ shk=1
+ dvthmat=(mv_nmosw_3n)*(0.67e-08/sqrt(ls*ws*ng)) dumat=(mu_nmosw_3n)*(4.9e-9/sqrt(ls*ws*ng))
//
if (modn==1)
nmosw_3n ( d g s b ) mosinsub w=ws l=ls nrd=8.0000e-07/ws nrs=8.0000e-07/ws ad=ad as=as pd=pd ps=ps m=ng
else
nmosw_3n ( d s ) resistor r=1e30
notvalid paramtest errorif=(modn==0) \
message="
***************************************************
*
* nmos is not valid in selected process option.
*
***************************************************"
model mosinsub bsim3v3 version=3.2400e+00  type=n  capmod=3.0000e+00 \
 mobmod=1.0000e+00  nqsmod=0.0000e+00  noimod=3.0000e+00 \
   vbox=1.000e+03      k1=4.6580e-01 \
     k2=0.0000e+00      k3=3.0270e-02     k3b=-1.089e-02 \
    nch=1.9540e+17 vth0=3.5220e-01+dvthmat \
   voff=-7.600e-02    dvt0=2.1160e+01    dvt1=1.0640e+00 \
   dvt2=3.0590e-02    keta=-1.200e-02 \
 pscbe1=1.0000e+30  pscbe2=1.0000e-06 \
 alpha0=1.9040e-06  alpha1=2.5000e+00   beta0=2.0000e+01 \
  dvt0w=2.0000e+00   dvt1w=1.6970e+06   dvt2w=-1.556e-02 \
     ua=-3.981e-10      ub=2.6890e-18      uc=6.9180e-11 \
u0=4.2940e+02+(4.2940e+02)*dumat \
   dsub=5.0000e-01    eta0=1.4790e-02    etab=-5.280e-02 \
nfactor=2.6780e-01 \
     em=4.1000e+07    pclm=9.6570e-01 \
  drout=5.0000e-01 \
     a0=2.0840e+00      a1=0.0000e+00      a2=1.0000e+00 \
   pvag=1.3460e-01    vsat=1.0200e+05     ags=3.6080e-01      b0=5.0200e-08      b1=1.0060e-07 \
  delta=2.3500e-03 pdiblcb=3.2150e-01 \
pdiblc1=2.3600e-01 pdiblc2=2.4880e-03 \
     w0=-3.185e-07 \
    dlc=-1.588e-08 \
dwc=-3.263e-01*l+1.5050e-07    dwb=0.0000e+00     dwg=-9.302e-09 \
     ll=1.0680e-13      lw=0.0000e+00     lwl=0.0000e+00 \
    lln=1.0000e+00     lwn=1.0000e+00      wl=2.8610e-13 \
     ww=-1.130e-14     wwl=-9.411e-21     wln=1.0000e+00 \
     wr=1.0000e+00     wwn=1.0000e+00 \
     at=2.5000e+04     ute=-1.700e+00 \
    kt1=-3.100e-01     kt2=-1.720e-02    kt1l=0.0000e+00 \
    ua1=0.0000e+00     ub1=0.0000e+00     uc1=0.0000e+00 \
    prt=3.0000e+01 \
   cgso=1.0850e-12    cgdo=1.0850e-12    cgbo=1.4960e-08 \
   cgdl=2.5110e-10    cgsl=2.5110e-10  ckappa=2.6020e+00 \
     cf=0.0000e+00     elm=5.0000e+00 \
  xpart=1.0000e+00     clc=1.0000e-15     cle=6.0000e-01 \
\
   rdsw=1.1390e+03 \
   cdsc=0.0000e+00   cdscb=1.5000e-09   cdscd=0.0000e+00 \
   prwb=-1.471e-01    prwg=1.3340e-02     cit=8.0260e-04 \
tox=7.1650e-09 \
  ngate=1.0000e+00 \
    nlx=1.7000e-07 \
     xl=-3.396e-08      xw=0.0000e+00 \
     af=1.3760e+00      kf=3.3960e-26      ef=1.0000e+00 \
   noia=1.3990e+20    noib=2.7070e+05    noic=-4.680e-12 \
     rd=0.0000e+00      rs=0.0000e+00     rsh=6.5000e+01 \
   minr=1.000e-03 \
    rdc=0.0000e+00     rsc=0.0000e+00 lint=-3.098e-07 \
wint=-8.216e-07   ldif=0.000e+00    hdif=8.0000e-07 \
     xj=3.0000e-07      js=5.1000e-07 \
      n=1.0000e+00 \
  dskip=no          tlev=0           tlevc=0         \
    jsw=6.0000e-13 \
     cj=6.2250e-04    cjsw=1.8750e-10 \
     fc=0.0000e+00    fcsw=0.000e+00 \
     mj=3.4000e-01    mjsw=2.3000e-01 \
     pb=6.9000e-01    pbsw=6.9000e-01     xti=2.0300e+00
ends nmosw_3n

// ----------------------------------------------------------------------

// ----------------------------------------------------------------------
// Owner: austriamicrosystems
// HIT-Kit: Digital
// ************************ SIMULATION PARAMETERS ************************
//  ----------------------------------------------------------------------
//  format    : Spectre (Spectre Direct)
//  model     : MOS BSIM3v3
//  process   : C35
//  revision  : 1.0;
//  extracted : C18069; 28.08.2011; bse (5866)
//  doc#      : Eng-?? REV_0
//  ----------------------------------------------------------------------
//                         WORST CASE POWER CONDITION
//
//  ----------------------------------------------------------------------
//
inline subckt nmosw_4n ( d g s b )
parameters w=1.0e-6 l=1.0e-6 nrd=0.0 nrs=0.0 ad=0.0 as=0.0 pd=0.0 ps=0.0 ng=1
+ ws= w
+ ls= l
+ shk=1
+ dvthmat=(mv_nmosw_4n)*(0.67e-08/sqrt(ls*ws*ng)) dumat=(mu_nmosw_4n)*(4.9e-9/sqrt(ls*ws*ng))
//
if (modn==1)
nmosw_4n ( d g s b ) mosinsub w=ws l=ls nrd=8.0000e-07/ws nrs=8.0000e-07/ws ad=ad as=as pd=pd ps=ps m=ng
else
nmosw_4n ( d s ) resistor r=1e30
notvalid paramtest errorif=(modn==0) \
message="
***************************************************
*
* nmos is not valid in selected process option.
*
***************************************************"
model mosinsub bsim3v3 version=3.2400e+00  type=n  capmod=3.0000e+00 \
 mobmod=1.0000e+00  nqsmod=0.0000e+00  noimod=3.0000e+00 \
   vbox=1.000e+03      k1=4.6580e-01 \
     k2=0.0000e+00      k3=3.0270e-02     k3b=-1.089e-02 \
    nch=1.9540e+17 vth0=3.5220e-01+dvthmat \
   voff=-7.600e-02    dvt0=2.1160e+01    dvt1=1.0640e+00 \
   dvt2=3.0590e-02    keta=-1.200e-02 \
 pscbe1=1.0000e+30  pscbe2=1.0000e-06 \
 alpha0=1.9040e-06  alpha1=2.5000e+00   beta0=2.0000e+01 \
  dvt0w=2.0000e+00   dvt1w=1.6970e+06   dvt2w=-1.556e-02 \
     ua=-3.981e-10      ub=2.5120e-18      uc=6.9180e-11 \
u0=4.2940e+02+(4.2940e+02)*dumat \
   dsub=5.0000e-01    eta0=1.4790e-02    etab=-5.280e-02 \
nfactor=2.6780e-01 \
     em=4.1000e+07    pclm=9.6570e-01 \
  drout=5.0000e-01 \
     a0=2.0840e+00      a1=0.0000e+00      a2=1.0000e+00 \
   pvag=1.3460e-01    vsat=1.0200e+05     ags=3.1620e-01      b0=5.0200e-08      b1=1.0060e-07 \
  delta=2.3500e-03 pdiblcb=3.2150e-01 \
pdiblc1=8.3400e-01 pdiblc2=2.4880e-03 \
     w0=-3.185e-07 \
    dlc=-1.588e-08 \
dwc=-3.263e-01*l+1.5050e-07    dwb=0.0000e+00     dwg=-9.302e-09 \
     ll=0.0000e+00      lw=0.0000e+00     lwl=0.0000e+00 \
    lln=1.0000e+00     lwn=1.0000e+00      wl=-1.924e-13 \
     ww=0.0000e+00     wwl=0.0000e+00     wln=1.0000e+00 \
     wr=1.0000e+00     wwn=1.0000e+00 \
     at=2.5000e+04     ute=-1.700e+00 \
    kt1=-3.100e-01     kt2=-1.720e-02    kt1l=0.0000e+00 \
    ua1=0.0000e+00     ub1=0.0000e+00     uc1=0.0000e+00 \
    prt=-2.456e+02 \
   cgso=1.0850e-12    cgdo=1.0850e-12    cgbo=1.4960e-08 \
   cgdl=2.5110e-10    cgsl=2.5110e-10  ckappa=2.6020e+00 \
     cf=0.0000e+00     elm=5.0000e+00 \
  xpart=1.0000e+00     clc=1.0000e-15     cle=6.0000e-01 \
\
   rdsw=1.1410e+03 \
   cdsc=0.0000e+00   cdscb=1.5000e-09   cdscd=0.0000e+00 \
   prwb=-7.244e-02    prwg=1.1740e-01     cit=8.0260e-04 \
tox=7.1650e-09 \
  ngate=1.0000e+00 \
    nlx=1.7000e-07 \
     xl=-4.190e-08      xw=0.0000e+00 \
     af=1.3760e+00      kf=3.3960e-26      ef=1.0000e+00 \
   noia=1.3990e+20    noib=2.7070e+05    noic=-4.680e-12 \
     rd=0.0000e+00      rs=0.0000e+00     rsh=6.5000e+01 \
   minr=1.000e-03 \
    rdc=0.0000e+00     rsc=0.0000e+00 lint=-1.868e-07 \
wint=-3.544e-07   ldif=0.000e+00    hdif=8.0000e-07 \
     xj=3.0000e-07      js=5.1000e-07 \
      n=1.0000e+00 \
  dskip=no          tlev=0           tlevc=0         \
    jsw=6.0000e-13 \
     cj=6.2250e-04    cjsw=1.8750e-10 \
     fc=0.0000e+00    fcsw=0.000e+00 \
     mj=3.4000e-01    mjsw=2.3000e-01 \
     pb=6.9000e-01    pbsw=6.9000e-01     xti=2.0300e+00
ends nmosw_4n

// ----------------------------------------------------------------------

// ----------------------------------------------------------------------
// Owner: austriamicrosystems
// HIT-Kit: Digital
// ************************ SIMULATION PARAMETERS ************************
//  ----------------------------------------------------------------------
//  format    : Spectre (Spectre Direct)
//  model     : MOS BSIM3v3
//  process   : C35
//  revision  : 1.0;
//  extracted : C18069; 28.08.2011; bse (5866)
//  doc#      : Eng-?? REV_0
//  ----------------------------------------------------------------------
//                         WORST CASE POWER CONDITION
//
//  ----------------------------------------------------------------------
//
inline subckt nmosmw_2n ( d g s b )
parameters w=1.0e-6 l=1.0e-6 nrd=0.0 nrs=0.0 ad=0.0 as=0.0 pd=0.0 ps=0.0 ng=1
+ ws= w
+ ls= l
+ shk=1
+ dvthmat=(mv_nmosmw_2n)*(1.03e-08/sqrt(ls*ws*ng)) dumat=(mu_nmosmw_2n)*(3.5e-9/sqrt(ls*ws*ng))
//
if (modnm==1)
nmosmw_2n ( d g s b ) mosinsub w=ws l=ls nrd=6.0000e-07/ws nrs=6.0000e-07/ws ad=ad as=as pd=pd ps=ps m=ng
else
nmosmw_2n ( d s ) resistor r=1e30
notvalid paramtest errorif=(modnm==0) \
message="
***************************************************
*
* nmosm is not valid in selected process option.
*
***************************************************"
model mosinsub bsim3v3 version=3.2400e+00  type=n  capmod=3.0000e+00 \
 mobmod=1.0000e+00  nqsmod=0.0000e+00  noimod=3.0000e+00 \
   vbox=1.000e+03      k1=8.4760e-01 \
     k2=0.0000e+00      k3=-2.500e+00     k3b=-5.640e-02 \
    nch=1.3360e+17 vth0=6.1630e-01+dvthmat \
   voff=-9.684e-02    dvt0=2.0510e+01    dvt1=1.0610e+00 \
   dvt2=2.5970e-02    keta=3.2000e-02 \
 pscbe1=1.0000e+30  pscbe2=1.0000e-06 \
 alpha0=5.5350e-08  alpha1=1.3930e-01   beta0=1.9570e+01 \
  dvt0w=1.0800e+01   dvt1w=3.0990e+06   dvt2w=1.4520e-01 \
     ua=1.4200e-12      ub=1.7380e-18      uc=5.7540e-11 \
u0=5.7350e+02+(5.7350e+02)*dumat \
   dsub=5.0000e-01    eta0=4.0860e-02    etab=-1.000e-03 \
nfactor=8.6050e-01 \
     em=4.1000e+07    pclm=9.0000e-01 \
  drout=5.0000e-01 \
     a0=1.0000e+00      a1=0.0000e+00      a2=1.0000e+00 \
   pvag=6.0000e-02    vsat=5.3380e+04     ags=1.9140e-01      b0=2.0000e-08      b1=1.0000e-08 \
  delta=1.0000e-02 pdiblcb=9.7980e-01 \
pdiblc1=2.4800e-01 pdiblc2=1.2400e-03 \
     w0=3.3160e-08 \
    dlc=1.3960e-09 \
dwc=-2.884e-01*l+1.4740e-07    dwb=8.6800e-09     dwg=-3.770e-09 \
     ll=7.4510e-14      lw=0.0000e+00     lwl=0.0000e+00 \
    lln=1.0000e+00     lwn=1.0000e+00      wl=-3.626e-13 \
     ww=-1.514e-14     wwl=-1.321e-20     wln=1.0000e+00 \
     wr=1.0000e+00     wwn=1.0000e+00 \
     at=3.3000e+04     ute=-1.720e+00 \
    kt1=-4.180e-01     kt2=-4.560e-02    kt1l=0.0000e+00 \
    ua1=0.0000e+00     ub1=0.0000e+00     uc1=0.0000e+00 \
    prt=0.0000e+00 \
   cgso=1.0050e-10    cgdo=1.0050e-10    cgbo=1.4080e-08 \
   cgdl=8.8000e-11    cgsl=8.8000e-11  ckappa=2.9570e+00 \
     cf=0.0000e+00     elm=5.0000e+00 \
  xpart=1.0000e+00     clc=1.0000e-15     cle=6.0000e-01 \
\
   rdsw=3.0420e+03 \
   cdsc=0.0000e+00   cdscb=2.0000e-03   cdscd=0.0000e+00 \
   prwb=5.0000e-02    prwg=4.3480e-03     cit=0.0000e+00 \
tox=1.4000e-08 \
  ngate=1.0000e+00 \
    nlx=1.5690e-07 \
     xl=-7.795e-08      xw=0.0000e+00 \
     af=1.3580e+00      kf=3.4460e-26      ef=1.0000e+00 \
   noia=1.7020e+20    noib=5.4630e+05    noic=-1.400e-11 \
     rd=0.0000e+00      rs=0.0000e+00     rsh=6.8470e+01 \
   minr=1.000e-03 \
    rdc=0.0000e+00     rsc=0.0000e+00 lint=-3.093e-07 \
wint=-8.560e-07   ldif=0.000e+00    hdif=6.0000e-07 \
     xj=3.0000e-07      js=5.1000e-07 \
      n=1.0000e+00 \
  dskip=no          tlev=0           tlevc=0         \
    jsw=6.0000e-13 \
     cj=6.2250e-04    cjsw=1.8750e-10 \
     fc=0.0000e+00    fcsw=0.000e+00 \
     mj=3.4000e-01    mjsw=2.3000e-01 \
     pb=6.9000e-01    pbsw=6.9000e-01     xti=2.0300e+00
ends nmosmw_2n

// ----------------------------------------------------------------------

// ----------------------------------------------------------------------
// Owner: austriamicrosystems
// HIT-Kit: Digital
// ************************ SIMULATION PARAMETERS ************************
//  ----------------------------------------------------------------------
//  format    : Spectre (Spectre Direct)
//  model     : MOS BSIM3v3
//  process   : C35
//  revision  : 1.0;
//  extracted : C18069; 28.08.2011; bse (5866)
//  doc#      : Eng-?? REV_0
//  ----------------------------------------------------------------------
//                         WORST CASE POWER CONDITION
//
//  ----------------------------------------------------------------------
//
inline subckt nmosmw_3n ( d g s b )
parameters w=1.0e-6 l=1.0e-6 nrd=0.0 nrs=0.0 ad=0.0 as=0.0 pd=0.0 ps=0.0 ng=1
+ ws= w
+ ls= l
+ shk=1
+ dvthmat=(mv_nmosmw_3n)*(1.03e-08/sqrt(ls*ws*ng)) dumat=(mu_nmosmw_3n)*(3.5e-9/sqrt(ls*ws*ng))
//
if (modnm==1)
nmosmw_3n ( d g s b ) mosinsub w=ws l=ls nrd=6.0000e-07/ws nrs=6.0000e-07/ws ad=ad as=as pd=pd ps=ps m=ng
else
nmosmw_3n ( d s ) resistor r=1e30
notvalid paramtest errorif=(modnm==0) \
message="
***************************************************
*
* nmosm is not valid in selected process option.
*
***************************************************"
model mosinsub bsim3v3 version=3.2400e+00  type=n  capmod=3.0000e+00 \
 mobmod=1.0000e+00  nqsmod=0.0000e+00  noimod=3.0000e+00 \
   vbox=1.000e+03      k1=8.4760e-01 \
     k2=0.0000e+00      k3=-2.500e+00     k3b=-5.640e-02 \
    nch=1.3360e+17 vth0=6.1630e-01+dvthmat \
   voff=-9.684e-02    dvt0=2.0510e+01    dvt1=1.0610e+00 \
   dvt2=2.5970e-02    keta=3.2000e-02 \
 pscbe1=1.0000e+30  pscbe2=1.0000e-06 \
 alpha0=5.5350e-08  alpha1=1.3930e-01   beta0=1.9570e+01 \
  dvt0w=1.0800e+01   dvt1w=3.0990e+06   dvt2w=1.4520e-01 \
     ua=1.4200e-12      ub=1.7380e-18      uc=5.7540e-11 \
u0=5.7350e+02+(5.7350e+02)*dumat \
   dsub=5.0000e-01    eta0=4.0860e-02    etab=-1.000e-03 \
nfactor=8.6050e-01 \
     em=4.1000e+07    pclm=9.0000e-01 \
  drout=5.0000e-01 \
     a0=1.0000e+00      a1=0.0000e+00      a2=1.0000e+00 \
   pvag=6.0000e-02    vsat=6.1710e+04     ags=1.9140e-01      b0=2.0000e-08      b1=1.0000e-08 \
  delta=1.0000e-02 pdiblcb=9.7980e-01 \
pdiblc1=1.4000e-01 pdiblc2=1.3490e-03 \
     w0=3.3160e-08 \
    dlc=1.3960e-09 \
dwc=-2.884e-01*l+1.4740e-07    dwb=8.6800e-09     dwg=-3.770e-09 \
     ll=7.4510e-14      lw=0.0000e+00     lwl=0.0000e+00 \
    lln=1.0000e+00     lwn=1.0000e+00      wl=-1.968e-13 \
     ww=-1.514e-14     wwl=-1.321e-20     wln=1.0000e+00 \
     wr=1.0000e+00     wwn=1.0000e+00 \
     at=3.3000e+04     ute=-1.720e+00 \
    kt1=-4.180e-01     kt2=-4.560e-02    kt1l=0.0000e+00 \
    ua1=0.0000e+00     ub1=0.0000e+00     uc1=0.0000e+00 \
    prt=0.0000e+00 \
   cgso=1.0050e-10    cgdo=1.0050e-10    cgbo=1.4080e-08 \
   cgdl=8.8440e-11    cgsl=8.8440e-11  ckappa=2.9570e+00 \
     cf=0.0000e+00     elm=5.0000e+00 \
  xpart=1.0000e+00     clc=1.0000e-15     cle=6.0000e-01 \
\
   rdsw=2.5390e+03 \
   cdsc=0.0000e+00   cdscb=2.0000e-03   cdscd=0.0000e+00 \
   prwb=5.0000e-02    prwg=4.3480e-03     cit=0.0000e+00 \
tox=1.4000e-08 \
  ngate=1.0000e+00 \
    nlx=1.5690e-07 \
     xl=-5.993e-08      xw=0.0000e+00 \
     af=1.3580e+00      kf=3.4460e-26      ef=1.0000e+00 \
   noia=1.7020e+20    noib=5.4630e+05    noic=-1.400e-11 \
     rd=0.0000e+00      rs=0.0000e+00     rsh=6.8470e+01 \
   minr=1.000e-03 \
    rdc=0.0000e+00     rsc=0.0000e+00 lint=-2.609e-07 \
wint=-6.127e-07   ldif=0.000e+00    hdif=6.0000e-07 \
     xj=3.0000e-07      js=5.1000e-07 \
      n=1.0000e+00 \
  dskip=no          tlev=0           tlevc=0         \
    jsw=6.0000e-13 \
     cj=6.2250e-04    cjsw=1.8750e-10 \
     fc=0.0000e+00    fcsw=0.000e+00 \
     mj=3.4000e-01    mjsw=2.3000e-01 \
     pb=6.9000e-01    pbsw=6.9000e-01     xti=2.0300e+00
ends nmosmw_3n

// ----------------------------------------------------------------------

// ----------------------------------------------------------------------
// Owner: austriamicrosystems
// HIT-Kit: Digital
// ************************ SIMULATION PARAMETERS ************************
//  ----------------------------------------------------------------------
//  format    : Spectre (Spectre Direct)
//  model     : MOS BSIM3v3
//  process   : C35
//  revision  : 1.0;
//  extracted : C18069; 28.08.2011; bse (5866)
//  doc#      : Eng-?? REV_0
//  ----------------------------------------------------------------------
//                         WORST CASE POWER CONDITION
//
//  ----------------------------------------------------------------------
//
inline subckt nmosmw_4n ( d g s b )
parameters w=1.0e-6 l=1.0e-6 nrd=0.0 nrs=0.0 ad=0.0 as=0.0 pd=0.0 ps=0.0 ng=1
+ ws= w
+ ls= l
+ shk=1
+ dvthmat=(mv_nmosmw_4n)*(1.03e-08/sqrt(ls*ws*ng)) dumat=(mu_nmosmw_4n)*(3.5e-9/sqrt(ls*ws*ng))
//
if (modnm==1)
nmosmw_4n ( d g s b ) mosinsub w=ws l=ls nrd=6.0000e-07/ws nrs=6.0000e-07/ws ad=ad as=as pd=pd ps=ps m=ng
else
nmosmw_4n ( d s ) resistor r=1e30
notvalid paramtest errorif=(modnm==0) \
message="
***************************************************
*
* nmosm is not valid in selected process option.
*
***************************************************"
model mosinsub bsim3v3 version=3.2400e+00  type=n  capmod=3.0000e+00 \
 mobmod=1.0000e+00  nqsmod=0.0000e+00  noimod=3.0000e+00 \
   vbox=1.000e+03      k1=8.4760e-01 \
     k2=0.0000e+00      k3=-2.500e+00     k3b=-5.640e-02 \
    nch=1.3360e+17 vth0=6.1630e-01+dvthmat \
   voff=-9.684e-02    dvt0=2.0510e+01    dvt1=1.0610e+00 \
   dvt2=2.5970e-02    keta=3.2000e-02 \
 pscbe1=1.0000e+30  pscbe2=1.0000e-06 \
 alpha0=5.5350e-08  alpha1=1.3930e-01   beta0=1.9570e+01 \
  dvt0w=1.0800e+01   dvt1w=3.0990e+06   dvt2w=1.4520e-01 \
     ua=4.5710e-10      ub=1.7380e-18      uc=5.7540e-11 \
u0=5.7350e+02+(5.7350e+02)*dumat \
   dsub=5.0000e-01    eta0=4.0860e-02    etab=-1.000e-03 \
nfactor=8.6050e-01 \
     em=4.1000e+07    pclm=9.0000e-01 \
  drout=5.0000e-01 \
     a0=1.0000e+00      a1=0.0000e+00      a2=1.0000e+00 \
   pvag=6.0000e-02    vsat=6.3000e+04     ags=1.4990e-01      b0=2.0000e-08      b1=1.0000e-08 \
  delta=1.0000e-02 pdiblcb=9.7980e-01 \
pdiblc1=3.2000e-02 pdiblc2=1.6680e-03 \
     w0=3.3160e-08 \
    dlc=1.3960e-09 \
dwc=-2.884e-01*l+1.4740e-07    dwb=8.6800e-09     dwg=-3.770e-09 \
     ll=6.7850e-14      lw=0.0000e+00     lwl=0.0000e+00 \
    lln=1.0000e+00     lwn=1.0000e+00      wl=-1.989e-13 \
     ww=-1.514e-14     wwl=-1.321e-20     wln=1.0000e+00 \
     wr=1.0000e+00     wwn=1.0000e+00 \
     at=3.3000e+04     ute=-1.720e+00 \
    kt1=-4.180e-01     kt2=-4.560e-02    kt1l=0.0000e+00 \
    ua1=0.0000e+00     ub1=0.0000e+00     uc1=0.0000e+00 \
    prt=0.0000e+00 \
   cgso=1.0050e-10    cgdo=1.0050e-10    cgbo=1.4080e-08 \
   cgdl=8.8000e-11    cgsl=8.8000e-11  ckappa=2.9570e+00 \
     cf=0.0000e+00     elm=5.0000e+00 \
  xpart=1.0000e+00     clc=1.0000e-15     cle=6.0000e-01 \
\
   rdsw=2.7670e+03 \
   cdsc=0.0000e+00   cdscb=2.0000e-03   cdscd=0.0000e+00 \
   prwb=2.0000e-02    prwg=1.0000e-02     cit=0.0000e+00 \
tox=1.4000e-08 \
  ngate=1.0000e+00 \
    nlx=1.5690e-07 \
     xl=-5.010e-08      xw=0.0000e+00 \
     af=1.3580e+00      kf=3.4460e-26      ef=1.0000e+00 \
   noia=1.7020e+20    noib=5.4630e+05    noic=-1.400e-11 \
     rd=0.0000e+00      rs=0.0000e+00     rsh=6.8470e+01 \
   minr=1.000e-03 \
    rdc=0.0000e+00     rsc=0.0000e+00 lint=-2.104e-07 \
wint=-7.006e-07   ldif=0.000e+00    hdif=6.0000e-07 \
     xj=3.0000e-07      js=5.1000e-07 \
      n=1.0000e+00 \
  dskip=no          tlev=0           tlevc=0         \
    jsw=6.0000e-13 \
     cj=6.2250e-04    cjsw=1.8750e-10 \
     fc=0.0000e+00    fcsw=0.000e+00 \
     mj=3.4000e-01    mjsw=2.3000e-01 \
     pb=6.9000e-01    pbsw=6.9000e-01     xti=2.0300e+00
ends nmosmw_4n

// ----------------------------------------------------------------------

// ----------------------------------------------------------------------
// Owner: austriamicrosystems
// HIT-Kit: Digital
// ************************ SIMULATION PARAMETERS ************************
//  ----------------------------------------------------------------------
//  format    : Spectre (Spectre Direct)
//  model     : MOS BSIM3v3
//  process   : C35
//  revision  : 1.0;
//  extracted : C18069; 28.08.2011; bse (5866)
//  doc#      : Eng-?? REV_0
//  ----------------------------------------------------------------------
//                         WORST CASE POWER CONDITION
//
//  ----------------------------------------------------------------------
//
inline subckt pmosw_2n ( d g s b )
parameters w=1.0e-6 l=1.0e-6 nrd=0.0 nrs=0.0 ad=0.0 as=0.0 pd=0.0 ps=0.0 ng=1
+ ws= w
+ ls= l
+ shk=1
+ dvthmat=(mv_pmosw_2n)*(1.03e-08/sqrt(ls*ws*ng)) dumat=(mu_pmosw_2n)*(4.89e-9/sqrt(ls*ws*ng))
//
if (modp==1)
pmosw_2n ( d g s b ) mosinsub w=ws l=ls nrd=8.0000e-07/ws nrs=8.0000e-07/ws ad=ad as=as pd=pd ps=ps m=ng
else
pmosw_2n ( d s ) resistor r=1e30
notvalid paramtest errorif=(modp==0) \
message="
***************************************************
*
* pmos is not valid in selected process option.
*
***************************************************"
model mosinsub bsim3v3 version=3.2400e+00  type=p  capmod=3.0000e+00 \
 mobmod=1.0000e+00  nqsmod=0.0000e+00  noimod=3.0000e+00 \
   vbox=1.000e+03      k1=2.4220e-01 \
     k2=0.0000e+00      k3=5.2000e+00     k3b=-1.000e+00 \
    nch=8.0000e+16 vth0=-6.346e-01+dvthmat \
   voff=-1.640e-01    dvt0=2.2000e+00    dvt1=6.3470e-01 \
   dvt2=5.3690e-02    keta=-7.600e-03 \
 pscbe1=1.0000e+30  pscbe2=1.0000e-06 \
 alpha0=1.0000e-09  alpha1=1.1750e-02   beta0=2.2870e+01 \
  dvt0w=1.0090e-01   dvt1w=7.3400e+04   dvt2w=-6.310e-03 \
     ua=4.1690e-10      ub=1.9050e-18      uc=-3.631e-11 \
u0=1.9140e+02+(1.9140e+02)*dumat \
   dsub=5.0000e-01    eta0=2.4000e-01    etab=-3.917e-03 \
nfactor=1.0000e+00 \
     em=4.1000e+07    pclm=3.3380e+00 \
  drout=5.0000e-01 \
     a0=9.0000e-01      a1=1.4440e-15      a2=5.0780e-01 \
   pvag=1.0000e-03    vsat=6.0900e+04     ags=2.1480e-01      b0=2.1920e-07      b1=0.0000e+00 \
  delta=1.0000e-02 pdiblcb=1.0000e-02 \
pdiblc1=8.9340e+02 pdiblc2=1.8000e-03 \
     w0=-1.500e-07 \
    dlc=-2.929e-08 \
dwc=-3.000e-01*l+1.5000e-07    dwb=-5.244e-09     dwg=-1.100e-08 \
     ll=3.5530e-15      lw=0.0000e+00     lwl=0.0000e+00 \
    lln=1.0000e+00     lwn=1.0000e+00      wl=-1.712e-12 \
     ww=-4.300e-14     wwl=-2.884e-21     wln=1.0000e+00 \
     wr=1.0000e+00     wwn=1.0000e+00 \
     at=3.3000e+04     ute=-1.300e+00 \
    kt1=-4.740e-01     kt2=-5.440e-02    kt1l=-1.600e-08 \
    ua1=0.0000e+00     ub1=-3.802e-19     uc1=0.0000e+00 \
    prt=0.0000e+00 \
   cgso=9.0000e-11    cgdo=9.0000e-11    cgbo=1.4960e-08 \
   cgdl=1.1920e-10    cgsl=1.1920e-10  ckappa=1.0000e-01 \
     cf=0.0000e+00     elm=5.0000e+00 \
  xpart=1.0000e+00     clc=1.0000e-15     cle=6.0000e-01 \
\
   rdsw=1.0660e+04 \
   cdsc=1.2000e-02   cdscb=9.0000e-03   cdscd=1.0000e-03 \
   prwb=1.9620e-02    prwg=-3.558e-02     cit=0.0000e+00 \
tox=7.2440e-09 \
  ngate=0.0000e+00 \
    nlx=3.0770e-08 \
     xl=-1.160e-07      xw=0.0000e+00 \
     af=1.4050e+00      kf=1.8270e-26      ef=1.0000e+00 \
   noia=7.0910e+18    noib=6.0740e+04    noic=3.7790e-13 \
     rd=0.0000e+00      rs=0.0000e+00     rsh=1.0600e+02 \
   minr=1.000e-03 \
    rdc=0.0000e+00     rsc=0.0000e+00 lint=-7.965e-07 \
wint=-1.959e-06   ldif=0.000e+00    hdif=8.0000e-07 \
     xj=3.0000e-07      js=2.8000e-07 \
      n=1.0000e+00 \
  dskip=no          tlev=0           tlevc=0         \
    jsw=3.7000e-13 \
     cj=1.0200e-03    cjsw=2.6250e-10 \
     fc=0.0000e+00    fcsw=0.000e+00 \
     mj=5.4000e-01    mjsw=4.6000e-01 \
     pb=1.0200e+00    pbsw=1.0200e+00     xti=1.9730e+00
ends pmosw_2n

// ----------------------------------------------------------------------

// ----------------------------------------------------------------------
// Owner: austriamicrosystems
// HIT-Kit: Digital
// ************************ SIMULATION PARAMETERS ************************
//  ----------------------------------------------------------------------
//  format    : Spectre (Spectre Direct)
//  model     : MOS BSIM3v3
//  process   : C35
//  revision  : 1.0;
//  extracted : C18069; 28.08.2011; bse (5866)
//  doc#      : Eng-?? REV_0
//  ----------------------------------------------------------------------
//                         WORST CASE POWER CONDITION
//
//  ----------------------------------------------------------------------
//
inline subckt pmosw_3n ( d g s b )
parameters w=1.0e-6 l=1.0e-6 nrd=0.0 nrs=0.0 ad=0.0 as=0.0 pd=0.0 ps=0.0 ng=1
+ ws= w
+ ls= l
+ shk=1
+ dvthmat=(mv_pmosw_3n)*(1.03e-08/sqrt(ls*ws*ng)) dumat=(mu_pmosw_3n)*(4.89e-9/sqrt(ls*ws*ng))
//
if (modp==1)
pmosw_3n ( d g s b ) mosinsub w=ws l=ls nrd=8.0000e-07/ws nrs=8.0000e-07/ws ad=ad as=as pd=pd ps=ps m=ng
else
pmosw_3n ( d s ) resistor r=1e30
notvalid paramtest errorif=(modp==0) \
message="
***************************************************
*
* pmos is not valid in selected process option.
*
***************************************************"
model mosinsub bsim3v3 version=3.2400e+00  type=p  capmod=3.0000e+00 \
 mobmod=1.0000e+00  nqsmod=0.0000e+00  noimod=3.0000e+00 \
   vbox=1.000e+03      k1=2.4220e-01 \
     k2=0.0000e+00      k3=5.2000e+00     k3b=-1.000e+00 \
    nch=8.0000e+16 vth0=-6.346e-01+dvthmat \
   voff=-1.640e-01    dvt0=2.2000e+00    dvt1=6.3470e-01 \
   dvt2=5.3690e-02    keta=-7.600e-03 \
 pscbe1=1.0000e+30  pscbe2=1.0000e-06 \
 alpha0=1.0000e-09  alpha1=1.1750e-02   beta0=2.2870e+01 \
  dvt0w=1.0090e-01   dvt1w=7.3400e+04   dvt2w=-6.310e-03 \
     ua=4.1690e-10      ub=1.9050e-18      uc=-3.631e-11 \
u0=1.9140e+02+(1.9140e+02)*dumat \
   dsub=5.0000e-01    eta0=2.4000e-01    etab=-3.917e-03 \
nfactor=1.0000e+00 \
     em=4.1000e+07    pclm=3.5650e+00 \
  drout=5.0000e-01 \
     a0=9.0000e-01      a1=1.4440e-15      a2=5.0780e-01 \
   pvag=4.6400e+00    vsat=1.0000e+05     ags=3.8020e-01      b0=2.1920e-07      b1=0.0000e+00 \
  delta=1.0000e-02 pdiblcb=1.0000e+00 \
pdiblc1=8.3320e+00 pdiblc2=2.0670e-03 \
     w0=-1.500e-07 \
    dlc=-2.929e-08 \
dwc=-3.000e-01*l+1.5000e-07    dwb=-5.244e-09     dwg=-1.100e-08 \
     ll=3.5530e-15      lw=0.0000e+00     lwl=0.0000e+00 \
    lln=1.0000e+00     lwn=1.0000e+00      wl=-5.064e-13 \
     ww=-4.300e-14     wwl=-2.884e-21     wln=1.0000e+00 \
     wr=1.0000e+00     wwn=1.0000e+00 \
     at=3.3000e+04     ute=-1.300e+00 \
    kt1=-4.740e-01     kt2=-5.440e-02    kt1l=-1.600e-08 \
    ua1=0.0000e+00     ub1=-3.802e-19     uc1=0.0000e+00 \
    prt=0.0000e+00 \
   cgso=9.0000e-11    cgdo=9.0000e-11    cgbo=1.4960e-08 \
   cgdl=1.1920e-10    cgsl=1.1920e-10  ckappa=1.0000e-01 \
     cf=0.0000e+00     elm=5.0000e+00 \
  xpart=1.0000e+00     clc=1.0000e-15     cle=6.0000e-01 \
\
   rdsw=5.7750e+03 \
   cdsc=1.2000e-02   cdscb=9.0000e-03   cdscd=1.0000e-03 \
   prwb=1.9620e-02    prwg=-1.019e-02     cit=0.0000e+00 \
tox=7.2440e-09 \
  ngate=0.0000e+00 \
    nlx=3.0770e-08 \
     xl=-8.408e-08      xw=0.0000e+00 \
     af=1.4050e+00      kf=1.8270e-26      ef=1.0000e+00 \
   noia=7.0910e+18    noib=6.0740e+04    noic=3.7790e-13 \
     rd=0.0000e+00      rs=0.0000e+00     rsh=1.0600e+02 \
   minr=1.000e-03 \
    rdc=0.0000e+00     rsc=0.0000e+00 lint=-3.275e-07 \
wint=-9.593e-07   ldif=0.000e+00    hdif=8.0000e-07 \
     xj=3.0000e-07      js=2.8000e-07 \
      n=1.0000e+00 \
  dskip=no          tlev=0           tlevc=0         \
    jsw=3.7000e-13 \
     cj=1.0200e-03    cjsw=2.6250e-10 \
     fc=0.0000e+00    fcsw=0.000e+00 \
     mj=5.4000e-01    mjsw=4.6000e-01 \
     pb=1.0200e+00    pbsw=1.0200e+00     xti=1.9730e+00
ends pmosw_3n

// ----------------------------------------------------------------------

// ----------------------------------------------------------------------
// Owner: austriamicrosystems
// HIT-Kit: Digital
// ************************ SIMULATION PARAMETERS ************************
//  ----------------------------------------------------------------------
//  format    : Spectre (Spectre Direct)
//  model     : MOS BSIM3v3
//  process   : C35
//  revision  : 1.0;
//  extracted : C18069; 28.08.2011; bse (5866)
//  doc#      : Eng-?? REV_0
//  ----------------------------------------------------------------------
//                         WORST CASE POWER CONDITION
//
//  ----------------------------------------------------------------------
//
inline subckt pmosw_4n ( d g s b )
parameters w=1.0e-6 l=1.0e-6 nrd=0.0 nrs=0.0 ad=0.0 as=0.0 pd=0.0 ps=0.0 ng=1
+ ws= w
+ ls= l
+ shk=1
+ dvthmat=(mv_pmosw_4n)*(1.03e-08/sqrt(ls*ws*ng)) dumat=(mu_pmosw_4n)*(4.89e-9/sqrt(ls*ws*ng))
//
if (modp==1)
pmosw_4n ( d g s b ) mosinsub w=ws l=ls nrd=8.0000e-07/ws nrs=8.0000e-07/ws ad=ad as=as pd=pd ps=ps m=ng
else
pmosw_4n ( d s ) resistor r=1e30
notvalid paramtest errorif=(modp==0) \
message="
***************************************************
*
* pmos is not valid in selected process option.
*
***************************************************"
model mosinsub bsim3v3 version=3.2400e+00  type=p  capmod=3.0000e+00 \
 mobmod=1.0000e+00  nqsmod=0.0000e+00  noimod=3.0000e+00 \
   vbox=1.000e+03      k1=2.4220e-01 \
     k2=0.0000e+00      k3=5.2000e+00     k3b=-1.000e+00 \
    nch=8.0000e+16 vth0=-6.346e-01+dvthmat \
   voff=-1.640e-01    dvt0=2.2000e+00    dvt1=6.3470e-01 \
   dvt2=5.3690e-02    keta=-7.600e-03 \
 pscbe1=1.0000e+30  pscbe2=1.0000e-06 \
 alpha0=1.0000e-09  alpha1=1.1750e-02   beta0=2.2870e+01 \
  dvt0w=1.0090e-01   dvt1w=7.3400e+04   dvt2w=-6.310e-03 \
     ua=4.1690e-10      ub=1.9050e-18      uc=-3.631e-11 \
u0=1.9140e+02+(1.9140e+02)*dumat \
   dsub=5.0000e-01    eta0=2.4000e-01    etab=-3.917e-03 \
nfactor=1.0000e+00 \
     em=4.1000e+07    pclm=3.5650e+00 \
  drout=5.0000e-01 \
     a0=9.0000e-01      a1=1.4440e-15      a2=5.0780e-01 \
   pvag=4.6400e+00    vsat=1.5480e+05     ags=3.8020e-01      b0=2.1920e-07      b1=0.0000e+00 \
  delta=1.0000e-02 pdiblcb=1.0000e+00 \
pdiblc1=5.6700e+00 pdiblc2=3.0670e-03 \
     w0=-1.500e-07 \
    dlc=-2.929e-08 \
dwc=-3.000e-01*l+1.5000e-07    dwb=-5.244e-09     dwg=-1.100e-08 \
     ll=3.5530e-15      lw=0.0000e+00     lwl=0.0000e+00 \
    lln=1.0000e+00     lwn=1.0000e+00      wl=-5.064e-13 \
     ww=-4.300e-14     wwl=-2.884e-21     wln=1.0000e+00 \
     wr=1.0000e+00     wwn=1.0000e+00 \
     at=3.3000e+04     ute=-1.300e+00 \
    kt1=-4.740e-01     kt2=-5.440e-02    kt1l=-1.600e-08 \
    ua1=0.0000e+00     ub1=-3.802e-19     uc1=0.0000e+00 \
    prt=0.0000e+00 \
   cgso=9.0000e-11    cgdo=9.0000e-11    cgbo=1.4960e-08 \
   cgdl=1.1920e-10    cgsl=1.1920e-10  ckappa=1.0000e-01 \
     cf=0.0000e+00     elm=5.0000e+00 \
  xpart=1.0000e+00     clc=1.0000e-15     cle=6.0000e-01 \
\
   rdsw=5.7750e+03 \
   cdsc=1.2000e-02   cdscb=9.0000e-03   cdscd=1.0000e-03 \
   prwb=1.9620e-02    prwg=-7.244e-03     cit=0.0000e+00 \
tox=7.2440e-09 \
  ngate=0.0000e+00 \
    nlx=3.0770e-08 \
     xl=-7.800e-08      xw=0.0000e+00 \
     af=1.4050e+00      kf=1.8270e-26      ef=1.0000e+00 \
   noia=7.0910e+18    noib=6.0740e+04    noic=3.7790e-13 \
     rd=0.0000e+00      rs=0.0000e+00     rsh=1.0600e+02 \
   minr=1.000e-03 \
    rdc=0.0000e+00     rsc=0.0000e+00 lint=-2.996e-07 \
wint=-6.844e-07   ldif=0.000e+00    hdif=8.0000e-07 \
     xj=3.0000e-07      js=2.8000e-07 \
      n=1.0000e+00 \
  dskip=no          tlev=0           tlevc=0         \
    jsw=3.7000e-13 \
     cj=1.0200e-03    cjsw=2.6250e-10 \
     fc=0.0000e+00    fcsw=0.000e+00 \
     mj=5.4000e-01    mjsw=4.6000e-01 \
     pb=1.0200e+00    pbsw=1.0200e+00     xti=1.9730e+00
ends pmosw_4n

// ----------------------------------------------------------------------

// ----------------------------------------------------------------------
// Owner: austriamicrosystems
// HIT-Kit: Digital
// ************************ SIMULATION PARAMETERS ************************
//  ----------------------------------------------------------------------
//  format    : Spectre (Spectre Direct)
//  model     : MOS BSIM3v3
//  process   : C35
//  revision  : 1.0;
//  extracted : C18069; 28.08.2011; bse (5866)
//  doc#      : Eng-?? REV_0
//  ----------------------------------------------------------------------
//                         WORST CASE POWER CONDITION
//
//  ----------------------------------------------------------------------
//
inline subckt pmosmw_2n ( d g s b )
parameters w=1.0e-6 l=1.0e-6 nrd=0.0 nrs=0.0 ad=0.0 as=0.0 pd=0.0 ps=0.0 ng=1
+ ws= w
+ ls= l
+ shk=1
+ dvthmat=(mv_pmosmw_2n)*(1.5e-08/sqrt(ls*ws*ng)) dumat=(mu_pmosmw_2n)*(4.3e-9/sqrt(ls*ws*ng))
//
if (modpm==1)
pmosmw_2n ( d g s b ) mosinsub w=ws l=ls nrd=6.0000e-07/ws nrs=6.0000e-07/ws ad=ad as=as pd=pd ps=ps m=ng
else
pmosmw_2n ( d s ) resistor r=1e30
notvalid paramtest errorif=(modpm==0) \
message="
***************************************************
*
* pmosm is not valid in selected process option.
*
***************************************************"
model mosinsub bsim3v3 version=3.2400e+00  type=p  capmod=3.0000e+00 \
 mobmod=1.0000e+00  nqsmod=0.0000e+00  noimod=3.0000e+00 \
   vbox=1.000e+03      k1=4.4140e-01 \
     k2=0.0000e+00      k3=1.8000e+00     k3b=-1.000e+00 \
    nch=7.6980e+16 vth0=-9.245e-01+dvthmat \
   voff=-1.148e-01    dvt0=1.7000e+00    dvt1=4.0100e-01 \
   dvt2=2.0050e-01    keta=2.0800e-02 \
 pscbe1=1.0000e+30  pscbe2=1.0000e-06 \
 alpha0=1.0000e-07  alpha1=3.1620e+00   beta0=4.2260e+01 \
  dvt0w=2.0000e-01   dvt1w=5.0000e+05   dvt2w=-3.200e+00 \
     ua=3.1000e-09      ub=2.2000e-19      uc=-8.318e-11 \
u0=2.5810e+02+(2.5810e+02)*dumat \
   dsub=5.0000e-01    eta0=1.7900e-03    etab=-2.948e-02 \
nfactor=7.0460e-01 \
     em=4.1000e+07    pclm=4.9580e+00 \
  drout=5.0000e-01 \
     a0=1.0000e+00      a1=6.0520e-05      a2=2.2110e-01 \
   pvag=1.0000e+00    vsat=5.0470e+04     ags=1.4450e-01      b0=1.3800e-07      b1=0.0000e+00 \
  delta=1.0000e-02 pdiblcb=6.0000e-02 \
pdiblc1=2.5900e+04 pdiblc2=2.4430e-03 \
     w0=-1.800e-07 \
    dlc=-1.766e-08 \
dwc=-2.953e-01*l+1.4210e-07    dwb=-4.580e-09     dwg=-6.295e-09 \
     ll=0.0000e+00      lw=0.0000e+00     lwl=0.0000e+00 \
    lln=1.0000e+00     lwn=1.0000e+00      wl=-3.685e-12 \
     ww=-3.900e-14     wwl=-4.467e-21     wln=1.0000e+00 \
     wr=1.0000e+00     wwn=1.0000e+00 \
     at=7.9640e+04     ute=-1.492e+00 \
    kt1=-5.480e-01     kt2=-6.000e-02    kt1l=-2.600e-08 \
    ua1=-2.630e-10     ub1=-3.311e-18     uc1=0.0000e+00 \
    prt=0.0000e+00 \
   cgso=1.0010e-10    cgdo=1.0010e-10    cgbo=7.0400e-09 \
   cgdl=9.4780e-11    cgsl=9.4780e-11  ckappa=1.3700e+00 \
     cf=0.0000e+00     elm=5.0000e+00 \
  xpart=1.0000e+00     clc=1.0000e-15     cle=6.0000e-01 \
\
   rdsw=1.0820e+04 \
   cdsc=1.2140e-03   cdscb=2.9450e-04   cdscd=0.0000e+00 \
   prwb=5.0700e-02    prwg=7.0360e-02     cit=5.2590e-05 \
tox=1.4000e-08 \
  ngate=0.0000e+00 \
    nlx=1.2500e-07 \
     xl=-1.800e-07      xw=0.0000e+00 \
     af=1.5640e+00      kf=4.8520e-26      ef=1.0000e+00 \
   noia=1.8720e+18    noib=3.4540e+04    noic=1.2460e-12 \
     rd=0.0000e+00      rs=0.0000e+00     rsh=1.0680e+02 \
   minr=1.000e-03 \
    rdc=0.0000e+00     rsc=0.0000e+00 lint=-1.646e-06 \
wint=-2.751e-06   ldif=0.000e+00    hdif=6.0000e-07 \
     xj=3.0000e-07      js=2.8000e-07 \
      n=1.0000e+00 \
  dskip=no          tlev=0           tlevc=0         \
    jsw=3.7000e-13 \
     cj=1.0200e-03    cjsw=2.6250e-10 \
     fc=0.0000e+00    fcsw=0.000e+00 \
     mj=5.4000e-01    mjsw=4.6000e-01 \
     pb=1.0200e+00    pbsw=1.0200e+00     xti=1.9700e+00
ends pmosmw_2n

// ----------------------------------------------------------------------

// ----------------------------------------------------------------------
// Owner: austriamicrosystems
// HIT-Kit: Digital
// ************************ SIMULATION PARAMETERS ************************
//  ----------------------------------------------------------------------
//  format    : Spectre (Spectre Direct)
//  model     : MOS BSIM3v3
//  process   : C35
//  revision  : 1.0;
//  extracted : C18069; 28.08.2011; bse (5866)
//  doc#      : Eng-?? REV_0
//  ----------------------------------------------------------------------
//                         WORST CASE POWER CONDITION
//
//  ----------------------------------------------------------------------
//
inline subckt pmosmw_3n ( d g s b )
parameters w=1.0e-6 l=1.0e-6 nrd=0.0 nrs=0.0 ad=0.0 as=0.0 pd=0.0 ps=0.0 ng=1
+ ws= w
+ ls= l
+ shk=1
+ dvthmat=(mv_pmosmw_3n)*(1.5e-08/sqrt(ls*ws*ng)) dumat=(mu_pmosmw_3n)*(4.3e-9/sqrt(ls*ws*ng))
//
if (modpm==1)
pmosmw_3n ( d g s b ) mosinsub w=ws l=ls nrd=6.0000e-07/ws nrs=6.0000e-07/ws ad=ad as=as pd=pd ps=ps m=ng
else
pmosmw_3n ( d s ) resistor r=1e30
notvalid paramtest errorif=(modpm==0) \
message="
***************************************************
*
* pmosm is not valid in selected process option.
*
***************************************************"
model mosinsub bsim3v3 version=3.2400e+00  type=p  capmod=3.0000e+00 \
 mobmod=1.0000e+00  nqsmod=0.0000e+00  noimod=3.0000e+00 \
   vbox=1.000e+03      k1=4.4140e-01 \
     k2=0.0000e+00      k3=1.8000e+00     k3b=-1.000e+00 \
    nch=7.6980e+16 vth0=-9.245e-01+dvthmat \
   voff=-1.148e-01    dvt0=1.7000e+00    dvt1=4.0100e-01 \
   dvt2=2.0050e-01    keta=2.0800e-02 \
 pscbe1=1.0000e+30  pscbe2=1.0000e-06 \
 alpha0=1.0000e-07  alpha1=3.1620e+00   beta0=4.2260e+01 \
  dvt0w=2.0000e-01   dvt1w=5.0000e+05   dvt2w=-3.200e+00 \
     ua=3.1000e-09      ub=2.2000e-19      uc=-1.553e-10 \
u0=2.5810e+02+(2.5810e+02)*dumat \
   dsub=5.0000e-01    eta0=1.7900e-03    etab=-2.948e-02 \
nfactor=7.0460e-01 \
     em=4.1000e+07    pclm=4.9580e+00 \
  drout=5.0000e-01 \
     a0=1.0000e+00      a1=6.0520e-05      a2=2.2110e-01 \
   pvag=-1.500e+00    vsat=4.9050e+04     ags=1.4450e-01      b0=1.3800e-07      b1=0.0000e+00 \
  delta=1.0000e-02 pdiblcb=6.0000e-02 \
pdiblc1=2.6560e+02 pdiblc2=2.6870e-03 \
     w0=-1.800e-07 \
    dlc=-1.766e-08 \
dwc=-2.953e-01*l+1.4210e-07    dwb=-4.580e-09     dwg=-6.295e-09 \
     ll=0.0000e+00      lw=0.0000e+00     lwl=0.0000e+00 \
    lln=1.0000e+00     lwn=1.0000e+00      wl=-2.315e-12 \
     ww=-3.900e-14     wwl=-4.467e-21     wln=1.0000e+00 \
     wr=1.0000e+00     wwn=1.0000e+00 \
     at=7.9640e+04     ute=-1.492e+00 \
    kt1=-5.480e-01     kt2=-6.000e-02    kt1l=-2.600e-08 \
    ua1=-2.630e-10     ub1=-3.311e-18     uc1=0.0000e+00 \
    prt=0.0000e+00 \
   cgso=1.0010e-10    cgdo=1.0010e-10    cgbo=7.0400e-09 \
   cgdl=9.4780e-11    cgsl=9.4780e-11  ckappa=1.3700e+00 \
     cf=0.0000e+00     elm=5.0000e+00 \
  xpart=1.0000e+00     clc=1.0000e-15     cle=6.0000e-01 \
\
   rdsw=1.1340e+04 \
   cdsc=1.2140e-03   cdscb=2.9450e-04   cdscd=0.0000e+00 \
   prwb=-5.503e-02    prwg=1.5470e-02     cit=5.2590e-05 \
tox=1.4000e-08 \
  ngate=0.0000e+00 \
    nlx=1.2500e-07 \
     xl=-1.700e-07      xw=0.0000e+00 \
     af=1.5640e+00      kf=4.8520e-26      ef=1.0000e+00 \
   noia=1.8720e+18    noib=3.4540e+04    noic=1.2460e-12 \
     rd=0.0000e+00      rs=0.0000e+00     rsh=1.0680e+02 \
   minr=1.000e-03 \
    rdc=0.0000e+00     rsc=0.0000e+00 lint=-1.020e-06 \
wint=-1.770e-06   ldif=0.000e+00    hdif=6.0000e-07 \
     xj=3.0000e-07      js=2.8000e-07 \
      n=1.0000e+00 \
  dskip=no          tlev=0           tlevc=0         \
    jsw=3.7000e-13 \
     cj=1.0200e-03    cjsw=2.6250e-10 \
     fc=0.0000e+00    fcsw=0.000e+00 \
     mj=5.4000e-01    mjsw=4.6000e-01 \
     pb=1.0200e+00    pbsw=1.0200e+00     xti=1.9700e+00
ends pmosmw_3n

// ----------------------------------------------------------------------

// ----------------------------------------------------------------------
// Owner: austriamicrosystems
// HIT-Kit: Digital
// ************************ SIMULATION PARAMETERS ************************
//  ----------------------------------------------------------------------
//  format    : Spectre (Spectre Direct)
//  model     : MOS BSIM3v3
//  process   : C35
//  revision  : 1.0;
//  extracted : C18069; 28.08.2011; bse (5866)
//  doc#      : Eng-?? REV_0
//  ----------------------------------------------------------------------
//                         WORST CASE POWER CONDITION
//
//  ----------------------------------------------------------------------
//
inline subckt pmosmw_4n ( d g s b )
parameters w=1.0e-6 l=1.0e-6 nrd=0.0 nrs=0.0 ad=0.0 as=0.0 pd=0.0 ps=0.0 ng=1
+ ws= w
+ ls= l
+ shk=1
+ dvthmat=(mv_pmosmw_4n)*(1.5e-08/sqrt(ls*ws*ng)) dumat=(mu_pmosmw_4n)*(4.3e-9/sqrt(ls*ws*ng))
//
if (modpm==1)
pmosmw_4n ( d g s b ) mosinsub w=ws l=ls nrd=6.0000e-07/ws nrs=6.0000e-07/ws ad=ad as=as pd=pd ps=ps m=ng
else
pmosmw_4n ( d s ) resistor r=1e30
notvalid paramtest errorif=(modpm==0) \
message="
***************************************************
*
* pmosm is not valid in selected process option.
*
***************************************************"
model mosinsub bsim3v3 version=3.2400e+00  type=p  capmod=3.0000e+00 \
 mobmod=1.0000e+00  nqsmod=0.0000e+00  noimod=3.0000e+00 \
   vbox=1.000e+03      k1=4.4140e-01 \
     k2=0.0000e+00      k3=1.8000e+00     k3b=-1.000e+00 \
    nch=7.6980e+16 vth0=-9.245e-01+dvthmat \
   voff=-1.148e-01    dvt0=1.7000e+00    dvt1=4.0100e-01 \
   dvt2=2.0050e-01    keta=2.0800e-02 \
 pscbe1=1.0000e+30  pscbe2=1.0000e-06 \
 alpha0=1.0000e-07  alpha1=3.1620e+00   beta0=4.2260e+01 \
  dvt0w=2.0000e-01   dvt1w=5.0000e+05   dvt2w=-3.200e+00 \
     ua=3.1000e-09      ub=2.2000e-19      uc=-8.318e-11 \
u0=2.5810e+02+(2.5810e+02)*dumat \
   dsub=5.0000e-01    eta0=1.7900e-03    etab=-2.948e-02 \
nfactor=7.0460e-01 \
     em=4.1000e+07    pclm=4.9580e+00 \
  drout=5.0000e-01 \
     a0=1.0000e+00      a1=6.0520e-05      a2=2.2110e-01 \
   pvag=-1.500e+00    vsat=6.7470e+04     ags=1.4450e-01      b0=1.3800e-07      b1=0.0000e+00 \
  delta=1.0000e-02 pdiblcb=6.0000e-02 \
pdiblc1=2.8350e+01 pdiblc2=3.8950e-03 \
     w0=-1.800e-07 \
    dlc=-1.766e-08 \
dwc=-2.953e-01*l+1.4210e-07    dwb=-4.580e-09     dwg=-6.295e-09 \
     ll=0.0000e+00      lw=0.0000e+00     lwl=0.0000e+00 \
    lln=1.0000e+00     lwn=1.0000e+00      wl=-1.534e-12 \
     ww=-3.900e-14     wwl=-4.467e-21     wln=1.0000e+00 \
     wr=1.0000e+00     wwn=1.0000e+00 \
     at=7.9640e+04     ute=-1.492e+00 \
    kt1=-5.480e-01     kt2=-6.000e-02    kt1l=-2.600e-08 \
    ua1=-2.630e-10     ub1=-3.311e-18     uc1=0.0000e+00 \
    prt=0.0000e+00 \
   cgso=1.0010e-10    cgdo=1.0010e-10    cgbo=7.0400e-09 \
   cgdl=9.4780e-11    cgsl=9.4780e-11  ckappa=1.3700e+00 \
     cf=0.0000e+00     elm=5.0000e+00 \
  xpart=1.0000e+00     clc=1.0000e-15     cle=6.0000e-01 \
\
   rdsw=6.6990e+03 \
   cdsc=1.2140e-03   cdscb=2.9450e-04   cdscd=0.0000e+00 \
   prwb=5.0700e-02    prwg=7.7360e-02     cit=5.2590e-05 \
tox=1.4000e-08 \
  ngate=0.0000e+00 \
    nlx=1.2500e-07 \
     xl=-1.341e-07      xw=0.0000e+00 \
     af=1.5640e+00      kf=4.8520e-26      ef=1.0000e+00 \
   noia=1.8720e+18    noib=3.4540e+04    noic=1.2460e-12 \
     rd=0.0000e+00      rs=0.0000e+00     rsh=1.0680e+02 \
   minr=1.000e-03 \
    rdc=0.0000e+00     rsc=0.0000e+00 lint=-7.278e-07 \
wint=-1.000e-06   ldif=0.000e+00    hdif=6.0000e-07 \
     xj=3.0000e-07      js=2.8000e-07 \
      n=1.0000e+00 \
  dskip=no          tlev=0           tlevc=0         \
    jsw=3.7000e-13 \
     cj=1.0200e-03    cjsw=2.6250e-10 \
     fc=0.0000e+00    fcsw=0.000e+00 \
     mj=5.4000e-01    mjsw=4.6000e-01 \
     pb=1.0200e+00    pbsw=1.0200e+00     xti=1.9700e+00
ends pmosmw_4n

// ----------------------------------------------------------------------

// ----------------------------------------------------------------------
// Owner: austriamicrosystems
// HIT-Kit: Digital
//************************ SIMULATION PARAMETERS ************************
// ----------------------------------------------------------------------
// format    : Spectre
// model     : MODNRF
// process   : CS ADFI
// revision  : 3.1;
// extracted : CSD C64330.04e3; 2002-09; kmo(5966)
// doc#      : ENG-188 REV_5
// ----------------------------------------------------------------------
//                        WORST CASE POWER CONDITION
// ----------------------------------------------------------------------
//
//  RF CMOS TRANSISTOR MODEL
//
//-----------------------------------------------------------------------
inline subckt modnrf ( d g s b )
parameters w=1.0e-6 l=1.0e-6 nrd=0.0 nrs=0.0 ad=0.0 as=0.0 pd=0.0 ps=0.0 ng=1
+ mmvth_modnrf=0.0 mmu0_modnrf=0.0
+ dvthmat=(mv_modnrf53+mmvth_modnrf)*(0.67e-08/sqrt(l*w*ng)) dumat=(mu_modnrf53+mmu0_modnrf)*(4.9e-9/sqrt(l*w*ng))
// //
if (modnrf==1){
// --------- Gate network ------------------------------
lg  (g 20 ) inductor l=1.000e-15
rg  (20 21 ) resistor r=((6.895e-04/w+4.758e+01 )/ng+(3.726e+05*w+2.740e+00)) isnoisy=yes
//
// --------- Drain network -----------------------------
ldrain ( d 13 ) inductor l=1.000e-15
rdrain ( 13 11 ) resistor r=(3.320e-04/(w*ng)+1.669e-01) isnoisy=yes
//
// --------- Source network -----------------------------
lsource ( s 33 ) inductor l=1.000e-15
rsource ( 33 31 ) resistor r=(3.320e-04/(w*ng)+1.669e-01) isnoisy=yes
//
// --------- Substrate network -------------------------
// Diodes are for n-type or p-type MOS transistors
//
djdb  ( 12 11 ) bulk_diode area=ad*ng perim=pd*ng
djsb  ( 32 31 ) bulk_diode area=as*ng perim=ps*ng
//
rsub1 ( 12 b ) resistor r=((0.000e+00/w+0.000e+00)/ng+(9.524e+06*w+(4.156e+01))) isnoisy=yes
rsub2 ( 32 b ) resistor r=((0.000e+00/w+0.000e+00)/ng+(9.524e+06*w+(4.156e+01))) isnoisy=yes
//
// --------- Ideal mos transistor ----------------------
modnrf ( 11 21 31 b ) mosinsub l=l w=w*ng ad=0.0 as=0.0 pd=0.0 ps=0.0 nrd=0 nrs=0
}else
modnrf ( d s ) resistor r=1e30
notvalid paramtest errorif=(modnrf==0) \
message="
***************************************************
*
* nmosrf is not valid in selected process option.
*
***************************************************"
// Intrinsic MOS transistor
model mosinsub bsim3v3 version=3.1 type=n  capmod=2.0000e+00 \
 mobmod=1.0000e+00  nqsmod=0.0000e+00  noimod=3 \
   vbox=1.000e+03      k1=4.5955e-01 \
     k2=9.4825e-03      k3=-1.715e+00     k3b=6.3250e-01 \
    nch=1.8730e+17 vth0=3.3550e-01+dvthmat \
   voff=-5.719e-02    dvt0=2.2270e+01    dvt1=1.0510e+00 \
   dvt2=3.3930e-03    keta=-6.207e-04 \
 pscbe1=2.7560e+08  pscbe2=9.6450e-06 \
 alpha0=0.0000e+00   beta0=3.0000e+01 \
  dvt0w=0.0000e+00   dvt1w=0.0000e+00   dvt2w=0.0000e+00 \
     ua=1.0000e-12      ub=4.8510e-18      uc=5.7560e-11 \
u0=6.4220e+02+(6.4220e+02)*dumat \
   dsub=5.0000e-01    eta0=3.0850e-02    etab=-3.947e-02 \
nfactor=1.1190e-01 \
     em=4.1000e+07    pclm=1.5270e+00 \
  drout=5.0000e-01 \
     a0=2.2080e+00      a1=0.0000e+00      a2=1.0000e+00 \
   pvag=0.0000e+00    vsat=7.5800e+04     ags=2.4900e-01      b0=-1.765e-08      b1=0.0000e+00 \
  delta=1.0000e-02 pdiblcb=2.5830e-01 \
pdiblc1=1.0760e-01 pdiblc2=1.4530e-03 \
     w0=1.1840e-07 \
    dlc=6.6050e-08 \
    dwc=2.6760e-08     dwb=0.0000e+00     dwg=0.0000e+00 \
     ll=0.000e+00      lw=0.000e+00     lwl=0.000e+00 \
    lln=1.000e+00     lwn=1.000e+00      wl=0.0000e+00 \
     ww=0.0000e+00     wwl=0.0000e+00     wln=1.0000e+00 \
     wr=1.0000e+00     wwn=1.0000e+00 \
     at=3.3000e+04     ute=-1.800e+00 \
    kt1=-3.302e-01     kt2=2.2000e-02    kt1l=0.0000e+00 \
    ua1=0.0000e+00     ub1=0.0000e+00     uc1=0.0000e+00 \
    prt=0.0000e+00 \
   cgso=1.8730e-10    cgdo=1.8730e-10    cgbo=1.0000e-10 \
   cgdl=7.8800e-11    cgsl=7.8800e-11  ckappa=6.0000e-01 \
     cf=0.0000e+00     elm=5.0000e+00 \
  xpart=1.0000e+00     clc=1.0000e-15     cle=6.0000e-01 \
\
   rdsw=0.0000e+00 \
   cdsc=0.0000e+00   cdscb=0.0000e+00   cdscd=8.4480e-05 \
   prwb=0.0000e+00    prwg=0.0000e+00     cit=1.0000e-03 \
tox=6.9000e-09 \
  ngate=0.0000e+00 \
    nlx=1.9180e-07 \
     xl=-5.000e-08      xw=1.0000e-07 \
     af=1.3760e+00      kf=3.3960e-26      ef=1.0000e+00 \
   noia=1.3990e+20    noib=2.7070e+05    noic=-4.680e-12 \
     rd=0.0000e+00      rs=0.0000e+00     rsh=8.2000e+01 \
   minr=1.000e-03 \
    rdc=0.0000e+00     rsc=0.0000e+00 lint=8.2850e-09 \
wint=2.6760e-08   ldif=0.000e+00    hdif=6.0000e-07 \
     xj=3.0000e-07      js=5.1000e-07 \
      n=1.0000e+00 \
  dskip=no          tlev=0           tlevc=0         \
    jsw=0.0000e+00 \
     cj=0.0000e+00    cjsw=0.0000e+00 \
     fc=0.0000e+00    fcsw=0.000e+00 \
     mj=3.1000e-01    mjsw=1.9000e-01 \
     pb=6.9000e-01    pbsw=6.9000e-01
// Bulk Diode Model
model bulk_diode diode level=1 dskip=no \
     is=5.100e-07      isw=0.600e-12       n=1.0000000       ns=1.0000000   \
    cjo=1.580e-03       m=3.100e-01 \
    cjsw=0.000e+00       mjsw=2.011E-01 \
     fc=0.000e+00      tt=0.000e+00      vj=6.900e-01      vjsw=6.672E-01  \
     kf=0.000e+00      eg=1.11e+00     xti=2.026e+00      af=1.000e+00
ends modnrf
// ----------------------------------------------------------------------
// ----------------------------------------------------------------------
// Owner: austriamicrosystems
// HIT-Kit: Digital
//************************ SIMULATION PARAMETERS ************************
// ----------------------------------------------------------------------
// format    : Spectre
// model     : MODPRF
// process   : C/B/S 35
// revision  : 3.1;
// extracted : C35B3 B11634.L1 04PA3; 2002-09; kmo(5966)
// doc#      : ENG-188 REV_5
// ----------------------------------------------------------------------
//                        WORST CASE POWER CONDITION
// ----------------------------------------------------------------------
//
//  RF CMOS TRANSISTOR MODEL
//
//-----------------------------------------------------------------------
inline subckt modprf ( d g s b )
parameters w=1.0e-6 l=1.0e-6 nrd=0.0 nrs=0.0 ad=0.0 as=0.0 pd=0.0 ps=0.0 ng=1
+ mmvth_modprf=0.0 mmu0_modprf=0.0
+ dvthmat=(mv_modprf53+mmvth_modprf)*(1.03e-08/sqrt(l*w*ng)) dumat=(mu_modprf53+mmu0_modprf)*(7.1e-9/sqrt(l*w*ng))
// //
if (modprf==1){
// --------- Gate network ------------------------------
lg  (g 20 ) inductor l=1.000e-15
rg  (20 21 ) resistor r=((-5.800e-04/w+2.884e+02 )/ng+(-5.394e+05*w+1.596e+00)) isnoisy=yes
//
// --------- Drain network -----------------------------
ldrain ( d 13 ) inductor l=1.000e-15
rdrain ( 13 11 ) resistor r=(8.051e-04/(w*ng)+1.731e+00) isnoisy=yes
//
// --------- Source network -----------------------------
lsource ( s 33 ) inductor l=1.000e-15
rsource ( 33 31 ) resistor r=(8.051e-04/(w*ng)+1.731e+00) isnoisy=yes
//
// --------- Substrate network -------------------------
// Diodes are for n-type or p-type MOS transistors
//
djdb  ( 11 12 ) bulk_diode area=ad*ng perim=pd*ng
djsb  ( 31 32 ) bulk_diode area=as*ng perim=ps*ng
//
rsub1 ( 12 b ) resistor r=((1.064e-04/w+1.682e+02)/ng+(1.724e+06*w+(-2.292e+00))) isnoisy=yes
rsub2 ( 32 b ) resistor r=((1.064e-04/w+1.682e+02)/ng+(1.724e+06*w+(-2.292e+00))) isnoisy=yes
//
// --------- Ideal mos transistor ----------------------
modprf ( 11 21 31 b ) mosinsub l=l w=w*ng ad=0.0 as=0.0 pd=0.0 ps=0.0 nrd=0 nrs=0
}else
modprf ( d s ) resistor r=1e30
notvalid paramtest errorif=(modprf==0) \
message="
***************************************************
*
* pmosrf is not valid in selected process option.
*
***************************************************"
// Intrinsic MOS transistor
model mosinsub bsim3v3 version=3.1 type=p  capmod=2.0000e+00 \
 mobmod=1.0000e+00  nqsmod=0.0000e+00  noimod=3 \
   vbox=1.000e+03      k1=2.8455e-01 \
     k2=2.9894e-02      k3=1.1030e+01     k3b=-7.580e-01 \
    nch=1.1000e+17 vth0=-6.299e-01+dvthmat \
   voff=-1.170e-01    dvt0=1.6500e+00    dvt1=3.8680e-01 \
   dvt2=1.6590e-02    keta=-1.440e-02 \
 pscbe1=5.0000e+09  pscbe2=1.0000e-04 \
 alpha0=0.0000e+00   beta0=3.0000e+01 \
  dvt0w=1.8790e-01   dvt1w=7.3350e+04   dvt2w=-6.312e-03 \
     ua=5.3940e-10      ub=3.9760e-19      uc=1.0000e-20 \
u0=1.4420e+02+(1.4420e+02)*dumat \
   dsub=5.0000e-01    eta0=2.4800e-01    etab=-3.917e-03 \
nfactor=1.2140e+00 \
     em=4.1000e+07    pclm=1.8290e+00 \
  drout=5.0000e-01 \
     a0=5.8500e-01      a1=0.0000e+00      a2=1.0000e+00 \
   pvag=0.0000e+00    vsat=4.8240e+04     ags=2.4680e-01      b0=8.8320e-08      b1=0.0000e+00 \
  delta=1.0000e-02 pdiblcb=1.0000e+00 \
pdiblc1=1.0000e-04 pdiblc2=1.0000e-20 \
     w0=1.0000e-10 \
    dlc=5.6730e-08 \
    dwc=3.4490e-08     dwb=0.0000e+00     dwg=0.0000e+00 \
     ll=0.000e+00      lw=0.000e+00     lwl=0.000e+00 \
    lln=1.000e+00     lwn=1.000e+00      wl=0.0000e+00 \
     ww=1.8940e-16     wwl=-1.981e-21     wln=1.0000e+00 \
     wr=1.0000e+00     wwn=1.0400e+00 \
     at=3.3000e+04     ute=-1.300e+00 \
    kt1=-5.403e-01     kt2=2.2000e-02    kt1l=0.0000e+00 \
    ua1=0.0000e+00     ub1=0.0000e+00     uc1=0.0000e+00 \
    prt=0.0000e+00 \
   cgso=1.0000e-12    cgdo=1.0000e-12    cgbo=1.0000e-10 \
   cgdl=2.2780e-10    cgsl=2.2780e-10  ckappa=6.0000e-01 \
     cf=0.0000e+00     elm=5.0000e+00 \
  xpart=1.0000e+00     clc=1.0000e-15     cle=6.0000e-01 \
\
   rdsw=0.0000e+00 \
   cdsc=2.5890e-03   cdscb=2.9430e-04   cdscd=4.3700e-04 \
   prwb=-9.731e-02    prwg=1.4770e-01     cit=0.0000e+00 \
tox=7.1000e-09 \
  ngate=0.0000e+00 \
    nlx=1.7700e-07 \
     xl=-6.000e-08      xw=8.0000e-08 \
     af=1.4050e+00      kf=1.8270e-26      ef=1.0000e+00 \
   noia=7.0910e+18    noib=6.0740e+04    noic=3.7790e-13 \
     rd=0.0000e+00      rs=0.0000e+00     rsh=1.2900e+02 \
   minr=1.000e-03 \
    rdc=0.0000e+00     rsc=0.0000e+00 lint=-1.164e-08 \
wint=3.4490e-08   ldif=0.000e+00    hdif=8.0000e-07 \
     xj=3.0000e-07      js=2.8000e-07 \
      n=1.0000e+00 \
  dskip=no          tlev=0           tlevc=0         \
    jsw=3.7000e-13 \
     cj=0.0000e+00    cjsw=0.0000e+00 \
     fc=0.0000e+00    fcsw=0.000e+00 \
     mj=5.6000e-01    mjsw=4.3000e-01 \
     pb=1.0200e+00    pbsw=1.0200e+00     xti=1.9700e+00
// Bulk Diode Model
model bulk_diode diode level=1 dskip=no \
     is=2.800e-07      isw=3.700e-13       n=1.0000000       ns=1.0000000   \
    cjo=1.526e-03       m=1.176e-01 \
    cjsw=0.000e+00       mjsw=4.300e-01 \
     fc=0.000e+00      tt=0.000e+00      vj=1.020e+00      vjsw=1.020e+00  \
     kf=0.000e+00      eg=1.11e+00     xti=1.973e+00      af=1.000e+00
ends modprf
// ----------------------------------------------------------------------
//-------------- END OF Section ------------------
endsection
section cmosws
//
// ----------------------------------------------------------------------
// Owner: austriamicrosystems
// HIT-Kit: Digital
// ************************ SIMULATION PARAMETERS ************************
//  ----------------------------------------------------------------------
//  format    : Spectre (Spectre Direct)
//  model     : MOS BSIM3v3
//  process   : C35
//  revision  : 4.0;
//  extracted : B10866 ; 2002-12; ese(5487)
//  doc#      : ENG-182 REV_6
//  ----------------------------------------------------------------------
//                         WORST CASE SPEED CONDITION
//
//  ----------------------------------------------------------------------
//
inline subckt modn ( d g s b )
parameters w=1.0e-6 l=1.0e-6 nrd=0.0 nrs=0.0 ad=0.0 as=0.0 pd=0.0 ps=0.0 ng=1
+ ws= w
+ ls= l
+ shk=1
+ dvthmat=(mv_modn)*(0.67e-08/sqrt(ls*ws*ng)) dumat=(mu_modn)*(4.9e-9/sqrt(ls*ws*ng))
//
if (modn==1)
modn ( d g s b ) mosinsub w=ws l=ls nrd=nrd nrs=nrs ad=ad as=as pd=pd ps=ps m=ng
else
modn ( d s ) resistor r=1e30
notvalid paramtest errorif=(modn==0) \
message="
***************************************************
*
* nmos is not valid in selected process option.
*
***************************************************"
model mosinsub bsim3v3 version=3.2400e+00  type=n  capmod=2.0000e+00 \
 mobmod=1.0000e+00  nqsmod=0.0000e+00  noimod=3 \
   vbox=1.000e+03      k1=6.6008e-01 \
     k2=2.1313e-02      k3=-1.136e+00     k3b=-4.399e-01 \
    nch=3.0940e+17 vth0=5.5790e-01+dvthmat \
   voff=-8.925e-02    dvt0=5.0000e+01    dvt1=1.0390e+00 \
   dvt2=-8.375e-03    keta=2.0320e-02 \
 pscbe1=1.0000e+30  pscbe2=1.0000e-06 \
 alpha0=2.6000e-06  alpha1=5.0000e+00   beta0=2.1000e+01 \
  dvt0w=1.0890e-01   dvt1w=6.6710e+04   dvt2w=-1.352e-02 \
     ua=4.7050e-12      ub=2.1370e-18      uc=1.0000e-20 \
u0=4.6710e+02+(4.6710e+02)*dumat \
   dsub=5.0000e-01    eta0=1.4150e-02    etab=-1.221e-01 \
nfactor=4.1360e-01 \
     em=4.1000e+07    pclm=6.9480e-01 \
  drout=5.0000e-01 \
     a0=2.5410e+00      a1=0.0000e+00      a2=1.0000e+00 \
   pvag=0.0000e+00    vsat=1.3380e+05     ags=2.4080e-01      b0=4.3010e-09      b1=0.0000e+00 \
  delta=1.4420e-02 pdiblcb=3.2220e-01 \
pdiblc1=3.5710e-01 pdiblc2=2.0650e-03 \
     w0=2.6730e-07 \
    dlc=3.0000e-08 \
    dwc=9.4030e-08     dwb=0.0000e+00     dwg=0.0000e+00 \
     ll=0.000e+00      lw=0.000e+00     lwl=0.000e+00 \
    lln=1.000e+00     lwn=1.000e+00      wl=0.0000e+00 \
     ww=-1.297e-14     wwl=-9.411e-21     wln=1.0000e+00 \
     wr=1.0000e+00     wwn=1.0000e+00 \
     at=3.3000e+04     ute=-1.800e+00 \
    kt1=-3.302e-01     kt2=2.2000e-02    kt1l=0.0000e+00 \
    ua1=0.0000e+00     ub1=0.0000e+00     uc1=0.0000e+00 \
    prt=0.0000e+00 \
   cgso=1.2000e-10    cgdo=1.2000e-10    cgbo=1.2000e-10 \
   cgdl=1.4700e-10    cgsl=1.4700e-10  ckappa=6.0000e-01 \
     cf=0.0000e+00     elm=5.0000e+00 \
  xpart=1.0000e+00     clc=1.0000e-15     cle=6.0000e-01 \
   noff=1.0000e+00  voffcv=0.0000e+00 \
   rdsw=3.4490e+02 \
   cdsc=0.0000e+00   cdscb=1.5000e-03   cdscd=1.0000e-03 \
   prwb=-2.416e-01    prwg=0.0000e+00     cit=4.4410e-04 \
tox=8.1000e-09 \
  ngate=0.0000e+00 \
    nlx=1.8880e-07 \
     xl=5.0000e-08      xw=-1.000e-07 \
     af=1.3760e+00      kf=3.3960e-26      ef=1.0000e+00 \
   noia=1.3990e+20    noib=2.7070e+05    noic=-4.680e-12 \
     rd=0.0000e+00      rs=0.0000e+00     rsh=8.5000e+01 \
   minr=1.000e-03 \
    rdc=0.0000e+00     rsc=0.0000e+00 lint=-5.005e-08 \
wint=9.4030e-08   ldif=0.000e+00    hdif=8.0000e-07 \
     xj=3.0000e-07      js=5.1000e-07 \
      n=1.0000e+00 \
  dskip=no          tlev=0           tlevc=0         \
    jsw=6.0000e-13 \
     cj=1.0520e-03    cjsw=2.8000e-10 \
     fc=0.0000e+00    fcsw=0.000e+00 \
     mj=3.4000e-01    mjsw=2.3000e-01 \
     pb=6.9000e-01    pbsw=6.9000e-01     xti=2.0260e+00
ends modn

// ----------------------------------------------------------------------
// ----------------------------------------------------------------------
// Owner: austriamicrosystems
// HIT-Kit: Digital
// ************************ SIMULATION PARAMETERS ************************
//  ----------------------------------------------------------------------
//  format    : Spectre (Spectre Direct)
//  model     : MOS BSIM3v3
//  process   : C35
//  revision  : 4.1;
//  extracted : B11004 ; 2002-12; ese(5487)
//  doc#      : ENG-182 REV_6
//  ----------------------------------------------------------------------
//                         WORST CASE SPEED CONDITION
//
//  ----------------------------------------------------------------------
//
inline subckt modnm ( d g s b )
parameters w=1.0e-6 l=1.0e-6 nrd=0.0 nrs=0.0 ad=0.0 as=0.0 pd=0.0 ps=0.0 ng=1
+ ws= w
+ ls= l
+ shk=1
+ dvthmat=(mv_modnm)*(1.03e-08/sqrt(ls*ws*ng)) dumat=(mu_modnm)*(3.5e-9/sqrt(ls*ws*ng))
//
if (modnm==1)
modnm ( d g s b ) mosinsub w=ws l=ls nrd=nrd nrs=nrs ad=ad as=as pd=pd ps=ps m=ng
else
modnm ( d s ) resistor r=1e30
notvalid paramtest errorif=(modnm==0) \
message="
***************************************************
*
* nmosm is not valid in selected process option.
*
***************************************************"
model mosinsub bsim3v3 version=3.2400e+00  type=n  capmod=2.0000e+00 \
 mobmod=1.0000e+00  nqsmod=0.0000e+00  noimod=3 \
   vbox=1.000e+03      k1=8.7089e-01 \
     k2=1.0873e-01      k3=-3.776e+00     k3b=-7.691e-02 \
    nch=2.4590e+17 vth0=8.2950e-01+dvthmat \
   voff=-8.295e-02    dvt0=3.0000e+01    dvt1=1.5280e+00 \
   dvt2=2.5290e-02    keta=3.5850e-02 \
 pscbe1=1.0000e+30  pscbe2=1.0000e-06 \
 alpha0=7.7410e-09  alpha1=3.9830e-01   beta0=2.0700e+01 \
  dvt0w=-5.000e+00   dvt1w=2.5780e+06   dvt2w=5.1050e-02 \
     ua=4.7080e-10      ub=1.4700e-18      uc=-4.342e-11 \
u0=5.0210e+02+(5.0210e+02)*dumat \
   dsub=5.0000e-01    eta0=3.7950e-02    etab=-7.653e-04 \
nfactor=8.5730e-01 \
     em=4.1000e+07    pclm=2.1250e-01 \
  drout=5.0000e-01 \
     a0=2.0640e+00      a1=0.0000e+00      a2=1.0000e+00 \
   pvag=0.0000e+00    vsat=1.0780e+05     ags=1.0790e-01      b0=-1.493e-07      b1=0.0000e+00 \
  delta=1.0000e-02 pdiblcb=5.1860e-01 \
pdiblc1=1.0000e-04 pdiblc2=5.4580e-04 \
     w0=1.6170e-07 \
    dlc=1.0000e-07 \
    dwc=1.6230e-07     dwb=0.0000e+00     dwg=0.0000e+00 \
     ll=0.000e+00      lw=0.000e+00     lwl=0.000e+00 \
    lln=1.000e+00     lwn=1.000e+00      wl=0.0000e+00 \
     ww=-5.117e-14     wwl=-5.704e-21     wln=1.0000e+00 \
     wr=1.0000e+00     wwn=1.0000e+00 \
     at=3.3000e+04     ute=-1.760e+00 \
    kt1=-4.502e-01     kt2=2.2000e-02    kt1l=0.0000e+00 \
    ua1=0.0000e+00     ub1=0.0000e+00     uc1=0.0000e+00 \
    prt=0.0000e+00 \
   cgso=1.0800e-10    cgdo=1.0800e-10    cgbo=1.2000e-10 \
   cgdl=2.5400e-10    cgsl=2.5400e-10  ckappa=6.0000e-01 \
     cf=0.0000e+00     elm=5.0000e+00 \
  xpart=1.0000e+00     clc=1.0000e-15     cle=6.0000e-01 \
   noff=1.0000e+00  voffcv=0.0000e+00 \
   rdsw=1.3900e+03 \
   cdsc=0.0000e+00   cdscb=-1.500e-03   cdscd=0.0000e+00 \
   prwb=-6.740e-02    prwg=0.0000e+00     cit=0.0000e+00 \
tox=1.6000e-08 \
  ngate=0.0000e+00 \
    nlx=2.2830e-07 \
     xl=8.0000e-08      xw=-1.500e-07 \
     af=1.3580e+00      kf=3.4460e-26      ef=1.0000e+00 \
   noia=1.7020e+20    noib=5.4630e+05    noic=-1.400e-11 \
     rd=0.0000e+00      rs=0.0000e+00     rsh=8.5000e+01 \
   minr=1.000e-03 \
    rdc=0.0000e+00     rsc=0.0000e+00 lint=1.2250e-07 \
wint=1.6230e-07   ldif=0.000e+00    hdif=6.0000e-07 \
     xj=3.0000e-07      js=5.1000e-07 \
      n=1.0000e+00 \
  dskip=no          tlev=0           tlevc=0         \
    jsw=6.0000e-13 \
     cj=1.0530e-03    cjsw=2.8000e-10 \
     fc=0.0000e+00    fcsw=0.000e+00 \
     mj=3.4000e-01    mjsw=2.3000e-01 \
     pb=6.9000e-01    pbsw=6.9000e-01     xti=2.0260e+00
ends modnm

// ----------------------------------------------------------------------

// ----------------------------------------------------------------------
// Owner: austriamicrosystems
// HIT-Kit: Digital
// ************************ SIMULATION PARAMETERS ************************
//  ----------------------------------------------------------------------
//  format    : Spectre (Spectre Direct)
//  model     : MOS BSIM3v3
//  process   : C35
//  revision  : 5.0;
//  extracted : B27167L1W5C45; 15-04-2007; bse (5866)
//  doc#      : Eng-182 REV_6
//  ----------------------------------------------------------------------
//                         WORST CASE SPEED CONDITION
//
//  ----------------------------------------------------------------------
//
inline subckt modnl ( d g s b )
parameters w=1.0e-6 l=1.0e-6 nrd=0.0 nrs=0.0 ad=0.0 as=0.0 pd=0.0 ps=0.0 ng=1
+ ws= w
+ ls= l
+ shk=1
+ dvthmat=(mv_modnl)*(0.67e-08/sqrt(ls*ws*ng)) dumat=(mu_modnl)*(4.9e-9/sqrt(ls*ws*ng))
//
if (modnl==1)
modnl ( d g s b ) mosinsub w=ws l=ls nrd=8.0000e-07/ws nrs=8.0000e-07/ws ad=ad as=as pd=pd ps=ps m=ng
else
modnl ( d s ) resistor r=1e30
notvalid paramtest errorif=(modnl==0) \
message="
***************************************************
*
* nmosl is not valid in selected process option.
*
***************************************************"
model mosinsub bsim3v3 version=3.2400e+00  type=n  capmod=2.0000e+00 \
 mobmod=1.0000e+00  nqsmod=0.0000e+00  noimod=3.0000e+00 \
   vbox=1.000e+03      k1=5.4000e-01 \
     k2=0.0000e+00      k3=7.6040e+00     k3b=0.0000e+00 \
    nch=2.7400e+17 vth0=5.0200e-01+dvthmat \
   voff=-8.000e-02    dvt0=1.2570e+01    dvt1=8.1290e-01 \
   dvt2=2.2200e-15    keta=-2.800e-03 \
 pscbe1=1.0000e+30  pscbe2=1.0000e-06 \
 alpha0=1.9000e-06  alpha1=1.0000e+00   beta0=2.0000e+01 \
  dvt0w=0.0000e+00   dvt1w=1.6970e+06   dvt2w=2.5060e-01 \
     ua=1.0000e-12      ub=2.1880e-18      uc=7.2440e-11 \
u0=4.2560e+02+(4.2560e+02)*dumat \
   dsub=5.0000e-01    eta0=5.1580e-02    etab=-6.600e-02 \
nfactor=1.0000e+00 \
     em=4.1000e+07    pclm=1.2650e+00 \
  drout=5.0000e-01 \
     a0=1.7080e+00      a1=0.0000e+00      a2=1.0000e+00 \
   pvag=3.1500e-01    vsat=9.4190e+04     ags=3.1620e-01      b0=2.6240e-08      b1=0.0000e+00 \
  delta=1.0000e-03 pdiblcb=3.6000e-01 \
pdiblc1=1.2970e-01 pdiblc2=1.9500e-03 \
     w0=2.5000e-06 \
    dlc=3.0000e-08 \
    dwc=9.5120e-08     dwb=0.0000e+00     dwg=-7.686e-09 \
     ll=6.3200e-15      lw=0.0000e+00     lwl=0.0000e+00 \
    lln=1.0000e+00     lwn=1.0000e+00      wl=0.0000e+00 \
     ww=-2.855e-14     wwl=-4.365e-21     wln=1.0000e+00 \
     wr=1.0000e+00     wwn=1.0000e+00 \
     at=1.0000e+04     ute=-1.700e+00 \
    kt1=-3.400e-01     kt2=-4.840e-02    kt1l=0.0000e+00 \
    ua1=0.0000e+00     ub1=0.0000e+00     uc1=0.0000e+00 \
    prt=0.0000e+00 \
   cgso=1.2000e-11    cgdo=1.2000e-11    cgbo=1.2000e-10 \
   cgdl=4.0000e-10    cgsl=4.0000e-10  ckappa=1.7010e+00 \
     cf=0.0000e+00     elm=5.0000e+00 \
  xpart=1.0000e+00     clc=1.0000e-15     cle=6.0000e-01 \
\
   rdsw=4.4670e+02 \
   cdsc=1.0000e-09   cdscb=0.0000e+00   cdscd=0.0000e+00 \
   prwb=0.0000e+00    prwg=1.9050e-02     cit=0.0000e+00 \
tox=8.1000e-09 \
  ngate=0.0000e+00 \
    nlx=1.4300e-07 \
     xl=8.6000e-08      xw=-3.596e-08 \
     af=1.4940e+00      kf=6.9860e-26      ef=1.0000e+00 \
   noia=9.8640e+19    noib=1.7020e+05    noic=-2.723e-12 \
     rd=0.0000e+00      rs=0.0000e+00     rsh=8.5000e+01 \
   minr=1.000e-03 \
    rdc=0.0000e+00     rsc=0.0000e+00 lint=-6.902e-09 \
wint=9.5120e-08   ldif=0.000e+00    hdif=8.0000e-07 \
     xj=3.0000e-07      js=5.1000e-07 \
      n=1.0000e+00 \
  dskip=no          tlev=0           tlevc=0         \
    jsw=6.0000e-13 \
     cj=9.9600e-04    cjsw=3.0000e-10 \
     fc=0.0000e+00    fcsw=0.000e+00 \
     mj=3.4000e-01    mjsw=2.3000e-01 \
     pb=6.9000e-01    pbsw=6.9000e-01     xti=2.0300e+00
ends modnl

// ----------------------------------------------------------------------

// ----------------------------------------------------------------------
// Owner: austriamicrosystems
// HIT-Kit: Digital
// ************************ SIMULATION PARAMETERS ************************
//  ----------------------------------------------------------------------
//  format    : Spectre (Spectre Direct)
//  model     : MOS BSIM3v3
//  process   : C35
//  revision  : 5.0;
//  extracted : B27167L1W5C45; 15-04-2007; bse (5866)
//  doc#      : Eng-182 REV_6
//  ----------------------------------------------------------------------
//                         WORST CASE SPEED CONDITION
//
//  ----------------------------------------------------------------------
//
inline subckt modnml ( d g s b )
parameters w=1.0e-6 l=1.0e-6 nrd=0.0 nrs=0.0 ad=0.0 as=0.0 pd=0.0 ps=0.0 ng=1
+ ws= w
+ ls= l
+ shk=1
+ dvthmat=(mv_modnml)*(0.95e-08/sqrt(ls*ws*ng)) dumat=(mu_modnml)*(3.5e-9/sqrt(ls*ws*ng))
//
if (modnml==1)
modnml ( d g s b ) mosinsub w=ws l=ls nrd=6.0000e-07/ws nrs=6.0000e-07/ws ad=ad as=as pd=pd ps=ps m=ng
else
modnml ( d s ) resistor r=1e30
notvalid paramtest errorif=(modnml==0) \
message="
***************************************************
*
* nmosml is not valid in selected process option.
*
***************************************************"
model mosinsub bsim3v3 version=3.2400e+00  type=n  capmod=2.0000e+00 \
 mobmod=1.0000e+00  nqsmod=0.0000e+00  noimod=3.0000e+00 \
   vbox=1.000e+03      k1=9.8000e-01 \
     k2=0.0000e+00      k3=-1.456e+00     k3b=-7.244e-01 \
    nch=1.7150e+17 vth0=6.7940e-01+dvthmat \
   voff=-8.684e-02    dvt0=1.6010e+01    dvt1=1.0610e+00 \
   dvt2=4.5970e-02    keta=1.9180e-02 \
 pscbe1=1.0000e+30  pscbe2=1.0000e-06 \
 alpha0=1.6220e-08  alpha1=1.3800e-01   beta0=2.1000e+01 \
  dvt0w=0.0000e+00   dvt1w=3.0990e+06   dvt2w=4.5170e-02 \
     ua=1.0000e-12      ub=2.2910e-18      uc=6.9180e-11 \
u0=4.2930e+02+(4.2930e+02)*dumat \
   dsub=5.0000e-01    eta0=5.1290e-02    etab=-5.126e-03 \
nfactor=9.6050e-01 \
     em=4.1000e+07    pclm=1.1380e+00 \
  drout=5.0000e-01 \
     a0=1.0460e+00      a1=0.0000e+00      a2=1.0000e+00 \
   pvag=5.0000e-02    vsat=8.4420e+04     ags=1.2000e-01      b0=0.0000e+00      b1=0.0000e+00 \
  delta=1.8640e-03 pdiblcb=9.7980e-01 \
pdiblc1=6.1030e-06 pdiblc2=7.2440e-04 \
     w0=3.3160e-08 \
    dlc=1.0000e-07 \
    dwc=1.1660e-07     dwb=5.8200e-09     dwg=-1.000e-09 \
     ll=-9.793e-15      lw=0.0000e+00     lwl=0.0000e+00 \
    lln=1.0000e+00     lwn=1.0000e+00      wl=0.0000e+00 \
     ww=-4.017e-14     wwl=-1.380e-21     wln=1.0000e+00 \
     wr=1.0000e+00     wwn=1.0000e+00 \
     at=4.3550e+04     ute=-1.720e+00 \
    kt1=-4.500e-01     kt2=-6.560e-02    kt1l=0.0000e+00 \
    ua1=2.7540e-10     ub1=0.0000e+00     uc1=0.0000e+00 \
    prt=2.0000e+02 \
   cgso=1.0000e-12    cgdo=1.0000e-12    cgbo=1.2000e-10 \
   cgdl=4.8600e-10    cgsl=4.8600e-10  ckappa=1.9040e+00 \
     cf=0.0000e+00     elm=5.0000e+00 \
  xpart=1.0000e+00     clc=1.0000e-15     cle=6.0000e-01 \
\
   rdsw=1.1940e+03 \
   cdsc=2.4000e-04   cdscb=-7.468e-04   cdscd=0.0000e+00 \
   prwb=5.2110e-02    prwg=-5.443e-02     cit=0.0000e+00 \
tox=1.6000e-08 \
  ngate=1.0000e+00 \
    nlx=2.3690e-07 \
     xl=9.3920e-08      xw=-2.400e-08 \
     af=1.4000e+00      kf=3.7700e-26      ef=1.0000e+00 \
   noia=1.5360e+20    noib=3.5840e+05    noic=-1.304e-11 \
     rd=0.0000e+00      rs=0.0000e+00     rsh=8.5000e+01 \
   minr=1.000e-03 \
    rdc=0.0000e+00     rsc=0.0000e+00 lint=1.1900e-07 \
wint=1.1660e-07   ldif=0.000e+00    hdif=6.0000e-07 \
     xj=3.0000e-07      js=5.1000e-07 \
      n=1.0000e+00 \
  dskip=no          tlev=0           tlevc=0         \
    jsw=6.0000e-13 \
     cj=9.9600e-03    cjsw=3.0000e-10 \
     fc=0.0000e+00    fcsw=0.000e+00 \
     mj=3.4000e-01    mjsw=2.3000e-01 \
     pb=6.9000e-01    pbsw=6.9000e-01     xti=2.0300e+00
ends modnml

// ----------------------------------------------------------------------
// ----------------------------------------------------------------------
// Owner: austriamicrosystems
// HIT-Kit: Digital
// ************************ SIMULATION PARAMETERS ************************
//  ----------------------------------------------------------------------
//  format    : Spectre (Spectre Direct)
//  model     : MOS BSIM3v3
//  process   : C35
//  revision  : 4.1;
//  extracted : C64685 ; 2002-12; ese(5487)
//  doc#      : ENG-182 REV_6
//  ----------------------------------------------------------------------
//                         WORST CASE SPEED CONDITION
//
//  ----------------------------------------------------------------------
//
inline subckt modpm ( d g s b )
parameters w=1.0e-6 l=1.0e-6 nrd=0.0 nrs=0.0 ad=0.0 as=0.0 pd=0.0 ps=0.0 ng=1
+ ws= w
+ ls= l
+ shk=1
+ dvthmat=(mv_modpm)*(1.5e-08/sqrt(ls*ws*ng)) dumat=(mu_modpm)*(7.1e-9/sqrt(ls*ws*ng))
//
if (modpm==1)
modpm ( d g s b ) mosinsub w=ws l=ls nrd=nrd nrs=nrs ad=ad as=as pd=pd ps=ps m=ng
else
modpm ( d s ) resistor r=1e30
notvalid paramtest errorif=(modpm==0) \
message="
***************************************************
*
* pmosm is not valid in selected process option.
*
***************************************************"
model mosinsub bsim3v3 version=3.2400e+00  type=p  capmod=2.0000e+00 \
 mobmod=1.0000e+00  nqsmod=0.0000e+00  noimod=3 \
   vbox=1.000e+03      k1=6.7315e-01 \
     k2=4.2664e-02      k3=8.3170e+00     k3b=-1.479e+00 \
    nch=9.4750e+16 vth0=-1.091e+00+dvthmat \
   voff=-1.148e-01    dvt0=5.3990e-01    dvt1=4.1120e-01 \
   dvt2=-9.479e-02    keta=3.0100e-02 \
 pscbe1=1.0000e+30  pscbe2=1.0000e-06 \
 alpha0=2.7100e-07  alpha1=1.9100e+00   beta0=3.4770e+01 \
  dvt0w=8.0990e-01   dvt1w=1.4800e+05   dvt2w=4.4040e-02 \
     ua=1.8000e-12      ub=2.2180e-18      uc=-7.278e-11 \
u0=1.2540e+02+(1.2540e+02)*dumat \
   dsub=5.0000e-01    eta0=9.7360e-02    etab=-2.948e-02 \
nfactor=7.0460e-01 \
     em=4.1000e+07    pclm=4.3950e+00 \
  drout=5.0000e-01 \
     a0=1.3860e+00      a1=0.0000e+00      a2=1.0000e+00 \
   pvag=0.0000e+00    vsat=1.4360e+05     ags=1.3640e-01      b0=1.9910e-08      b1=0.0000e+00 \
  delta=1.0000e-02 pdiblcb=1.0000e+00 \
pdiblc1=2.0370e-02 pdiblc2=1.0000e-20 \
     w0=1.0000e-10 \
    dlc=2.5000e-08 \
    dwc=6.2030e-08     dwb=0.0000e+00     dwg=0.0000e+00 \
     ll=0.000e+00      lw=0.000e+00     lwl=0.000e+00 \
    lln=1.000e+00     lwn=1.000e+00      wl=0.0000e+00 \
     ww=-9.750e-16     wwl=-1.787e-21     wln=1.0000e+00 \
     wr=1.0000e+00     wwn=1.0400e+00 \
     at=3.3000e+04     ute=-1.300e+00 \
    kt1=-6.003e-01     kt2=2.2000e-02    kt1l=0.0000e+00 \
    ua1=0.0000e+00     ub1=0.0000e+00     uc1=0.0000e+00 \
    prt=0.0000e+00 \
   cgso=9.1000e-11    cgdo=9.1000e-11    cgbo=1.2000e-10 \
   cgdl=6.8000e-11    cgsl=6.8000e-11  ckappa=6.0000e-01 \
     cf=0.0000e+00     elm=5.0000e+00 \
  xpart=1.0000e+00     clc=1.0000e-15     cle=6.0000e-01 \
   noff=1.0000e+00  voffcv=0.0000e+00 \
   rdsw=1.6230e+03 \
   cdsc=1.2140e-03   cdscb=2.9450e-04   cdscd=0.0000e+00 \
   prwb=-4.521e-01    prwg=0.0000e+00     cit=5.2590e-05 \
tox=1.6000e-08 \
  ngate=0.0000e+00 \
    nlx=2.2310e-07 \
     xl=9.0000e-08      xw=-1.000e-07 \
     af=1.5640e+00      kf=4.8520e-26      ef=1.0000e+00 \
   noia=1.8720e+18    noib=3.4540e+04    noic=1.2460e-12 \
     rd=0.0000e+00      rs=0.0000e+00     rsh=1.6120e+02 \
   minr=1.000e-03 \
    rdc=0.0000e+00     rsc=0.0000e+00 lint=-8.504e-08 \
wint=6.2030e-08   ldif=0.000e+00    hdif=6.0000e-07 \
     xj=3.0000e-07      js=2.8000e-07 \
      n=1.0000e+00 \
  dskip=no          tlev=0           tlevc=0         \
    jsw=3.7000e-13 \
     cj=1.5230e-03    cjsw=3.5840e-10 \
     fc=0.0000e+00    fcsw=0.000e+00 \
     mj=5.4000e-01    mjsw=4.6000e-01 \
     pb=1.0200e+00    pbsw=1.0200e+00     xti=1.9700e+00
ends modpm

// ----------------------------------------------------------------------

// ----------------------------------------------------------------------
// Owner: austriamicrosystems
// HIT-Kit: Digital
// ************************ SIMULATION PARAMETERS ************************
//  ----------------------------------------------------------------------
//  format    : Spectre (Spectre Direct)
//  model     : MOS BSIM3v3
//  process   : C35
//  revision  : 5.0;
//  extracted : B27167L1W5C45; 15-04-2007; bse (5866)
//  doc#      : Eng-182 REV_6
//  ----------------------------------------------------------------------
//                         WORST CASE SPEED CONDITION
//
//  ----------------------------------------------------------------------
//
inline subckt modpml ( d g s b )
parameters w=1.0e-6 l=1.0e-6 nrd=0.0 nrs=0.0 ad=0.0 as=0.0 pd=0.0 ps=0.0 ng=1
+ ws= w
+ ls= l
+ shk=1
+ dvthmat=(mv_modpml)*(1.8e-08/sqrt(ls*ws*ng)) dumat=(mu_modpml)*(6.3e-9/sqrt(ls*ws*ng))
//
if (modpml==1)
modpml ( d g s b ) mosinsub w=ws l=ls nrd=6.0000e-07/ws nrs=6.0000e-07/ws ad=ad as=as pd=pd ps=ps m=ng
else
modpml ( d s ) resistor r=1e30
notvalid paramtest errorif=(modpml==0) \
message="
***************************************************
*
* pmosml is not valid in selected process option.
*
***************************************************"
model mosinsub bsim3v3 version=3.2400e+00  type=p  capmod=2.0000e+00 \
 mobmod=1.0000e+00  nqsmod=0.0000e+00  noimod=3.0000e+00 \
   vbox=1.000e+03      k1=6.7600e-01 \
     k2=-4.000e-03      k3=1.7420e+01     k3b=-1.738e+00 \
    nch=7.8980e+16 vth0=-7.880e-01+dvthmat \
   voff=-1.960e-01    dvt0=1.0000e+00    dvt1=4.2050e-01 \
   dvt2=-4.410e-02    keta=6.0000e-03 \
 pscbe1=1.0000e+30  pscbe2=1.0000e-06 \
 alpha0=1.3000e-07  alpha1=3.3320e-02   beta0=2.4820e+01 \
  dvt0w=5.7320e-01   dvt1w=2.8750e+05   dvt2w=1.6680e-01 \
     ua=3.3110e-09      ub=1.0000e-19      uc=-8.710e-11 \
u0=2.0610e+02+(2.0610e+02)*dumat \
   dsub=5.0000e-01    eta0=1.2500e-01    etab=-3.726e-04 \
nfactor=1.0210e+00 \
     em=4.1000e+07    pclm=2.5000e+00 \
  drout=5.0000e-01 \
     a0=1.1720e+00      a1=-1.581e-01      a2=1.0000e+00 \
   pvag=0.0000e+00    vsat=1.5690e+05     ags=1.4450e-01      b0=6.1800e-08      b1=0.0000e+00 \
  delta=2.9180e-02 pdiblcb=8.4520e-01 \
pdiblc1=1.1270e-02 pdiblc2=1.2500e-03 \
     w0=1.3800e-06 \
    dlc=4.5000e-08 \
    dwc=1.2300e-07     dwb=5.5110e-09     dwg=-5.171e-09 \
     ll=0.0000e+00      lw=0.0000e+00     lwl=0.0000e+00 \
    lln=1.0000e+00     lwn=1.0000e+00      wl=0.0000e+00 \
     ww=-4.460e-14     wwl=0.0000e+00     wln=1.0000e+00 \
     wr=1.0000e+00     wwn=1.0000e+00 \
     at=3.0000e+03     ute=-1.628e+00 \
    kt1=-6.603e-01     kt2=-8.840e-02    kt1l=0.0000e+00 \
    ua1=-2.399e-09     ub1=0.0000e+00     uc1=0.0000e+00 \
    prt=0.0000e+00 \
   cgso=6.4000e-11    cgdo=6.4000e-11    cgbo=1.2000e-10 \
   cgdl=1.8000e-10    cgsl=1.8000e-10  ckappa=1.4370e+00 \
     cf=0.0000e+00     elm=5.0000e+00 \
  xpart=1.0000e+00     clc=1.0000e-15     cle=6.0000e-01 \
\
   rdsw=6.3530e+02 \
   cdsc=1.4540e-04   cdscb=-2.792e-05   cdscd=0.0000e+00 \
   prwb=-3.097e-01    prwg=0.0000e+00     cit=0.0000e+00 \
tox=1.6000e-08 \
  ngate=1.0000e+00 \
    nlx=2.9510e-07 \
     xl=1.4990e-07      xw=-7.920e-09 \
     af=1.4710e+00      kf=1.3230e-26      ef=1.0000e+00 \
   noia=1.1970e+19    noib=2.6610e+04    noic=6.7840e-13 \
     rd=0.0000e+00      rs=0.0000e+00     rsh=1.6500e+02 \
   minr=1.000e-03 \
    rdc=0.0000e+00     rsc=0.0000e+00 lint=-7.553e-08 \
wint=1.2300e-07   ldif=0.000e+00    hdif=6.0000e-07 \
     xj=3.0000e-07      js=2.8000e-07 \
      n=1.0000e+00 \
  dskip=no          tlev=0           tlevc=0         \
    jsw=3.7000e-13 \
     cj=1.6320e-03    cjsw=4.2000e-10 \
     fc=0.0000e+00    fcsw=0.000e+00 \
     mj=5.4000e-01    mjsw=4.6000e-01 \
     pb=1.0200e+00    pbsw=1.0200e+00     xti=1.9700e+00
ends modpml

// ----------------------------------------------------------------------
//----------------------------------------------------------------------
//************************* SIMULATION PARAMETERS ************************
// ----------------------------------------------------------------------
// format    : Spectre ( Spectre Direct )
// model     : DIODE
// process   : C35
// revision  : 4.0;
// extracted : B10866 ; 2002-12; ese(5487)
// doc#      : ENG-182 REV_6
// ----------------------------------------------------------------------
//                       WORST CASE SPEED CONDITION
// ----------------------------------------------------------------------
// TERMINALS: A=anode=P-region C=cathode=N-region
// VARIABLES: M (mulitiplier), AREA [m^2], PERI [m].
// NOTE: The role of a protection DIODE is to conduct ESD current to VDD
// (or from VSS). This forward bias is NOT modelled, only leakage current
// and capacitance during normal operation. Any inductive load etc that
// will give forward bias, must be limited by other components to within
// Operating Conditions, otherwise parasitic bipolar action can occur.
//
// Parameters: area perim
//
inline subckt nd ( a c )
parameters area=1.0e-12 perimeter=1.0e-6
//
if (subdiode==1)
nd ( a c ) diodeinsub area=area perim=perimeter region=off
else
nd ( a c ) resistor r=1e30
notvalid paramtest errorif=(subdiode==0) \
message="
***************************************************
*
* subdiode is not valid in selected process option.
*
***************************************************"
model diodeinsub diode level=1 dskip=no \
     is=5.1000e-07     isw=6.0000e-13       n=1.0000e+00      ns=1.0000e+00 \
   minr=0.100e+00    imax=(1.000e+00/area) \
    cjo=1.0520e-03       m=3.4000e-01      vj=6.9000e-01      tt=0.000e+00 \
    xti=2.0260e+00 \
   cjsw=2.8000e-10    mjsw=2.3000e-01    vjsw=6.9000e-01      fc=0.000e+00 \
     af=1.000e+00      kf=0.000e+00
ends nd
// ----------------------------------------------------------------------
// Owner: austriamicrosystems
// HIT-Kit: Digital
// ************************ SIMULATION PARAMETERS ************************
//  ----------------------------------------------------------------------
//  format    : Spectre (Spectre Direct)
//  model     : MOS BSIM3v3
//  process   : C35
//  revision  : 4.1;
//  extracted : C64685 ; 2002-12; ese(5487)
//  doc#      : ENG-182 REV_6
//  ----------------------------------------------------------------------
//                         WORST CASE SPEED CONDITION
//
//  ----------------------------------------------------------------------
//
inline subckt modp ( d g s b )
parameters w=1.0e-6 l=1.0e-6 nrd=0.0 nrs=0.0 ad=0.0 as=0.0 pd=0.0 ps=0.0 ng=1
+ ws= w
+ ls= l
+ shk=1
+ dvthmat=(mv_modp)*(1.03e-08/sqrt(ls*ws*ng)) dumat=(mu_modp)*(7.1e-9/sqrt(ls*ws*ng))
//
if (modp==1)
modp ( d g s b ) mosinsub w=ws l=ls nrd=nrd nrs=nrs ad=ad as=as pd=pd ps=ps m=ng
else
modp ( d s ) resistor r=1e30
notvalid paramtest errorif=(modp==0) \
message="
***************************************************
*
* pmos is not valid in selected process option.
*
***************************************************"
model mosinsub bsim3v3 version=3.2400e+00  type=p  capmod=2.0000e+00 \
 mobmod=1.0000e+00  nqsmod=0.0000e+00  noimod=3 \
   vbox=1.000e+03      k1=6.2895e-01 \
     k2=-4.725e-02      k3=1.1030e+01     k3b=-7.580e-01 \
    nch=1.1460e+17 vth0=-7.715e-01+dvthmat \
   voff=-1.170e-01    dvt0=1.6500e+00    dvt1=3.8680e-01 \
   dvt2=1.6590e-02    keta=-1.440e-02 \
 pscbe1=1.0000e+30  pscbe2=1.0000e-06 \
 alpha0=1.0000e-09  alpha1=1.5000e+00   beta0=3.2500e+01 \
  dvt0w=1.8790e-01   dvt1w=7.3350e+04   dvt2w=-6.312e-03 \
     ua=5.3940e-10      ub=1.0530e-18      uc=1.0000e-20 \
u0=1.3140e+02+(1.3140e+02)*dumat \
   dsub=5.0000e-01    eta0=2.4800e-01    etab=-3.917e-03 \
nfactor=1.2140e+00 \
     em=4.1000e+07    pclm=3.1840e+00 \
  drout=5.0000e-01 \
     a0=5.8500e-01      a1=0.0000e+00      a2=1.0000e+00 \
   pvag=0.0000e+00    vsat=1.1580e+05     ags=2.4680e-01      b0=8.8320e-08      b1=0.0000e+00 \
  delta=1.0000e-02 pdiblcb=1.0000e+00 \
pdiblc1=1.0000e-04 pdiblc2=1.0000e-20 \
     w0=1.0000e-10 \
    dlc=2.4500e-08 \
    dwc=3.4490e-08     dwb=0.0000e+00     dwg=0.0000e+00 \
     ll=0.000e+00      lw=0.000e+00     lwl=0.000e+00 \
    lln=1.000e+00     lwn=1.000e+00      wl=0.0000e+00 \
     ww=1.8940e-16     wwl=-1.981e-21     wln=1.0000e+00 \
     wr=1.0000e+00     wwn=1.0400e+00 \
     at=3.3000e+04     ute=-1.300e+00 \
    kt1=-5.403e-01     kt2=2.2000e-02    kt1l=0.0000e+00 \
    ua1=0.0000e+00     ub1=0.0000e+00     uc1=0.0000e+00 \
    prt=0.0000e+00 \
   cgso=8.6000e-11    cgdo=8.6000e-11    cgbo=1.2000e-10 \
   cgdl=1.2100e-10    cgsl=1.2100e-10  ckappa=6.0000e-01 \
     cf=0.0000e+00     elm=5.0000e+00 \
  xpart=1.0000e+00     clc=1.0000e-15     cle=6.0000e-01 \
   noff=1.0000e+00  voffcv=0.0000e+00 \
   rdsw=1.0330e+03 \
   cdsc=2.5890e-03   cdscb=2.9430e-04   cdscd=4.3700e-04 \
   prwb=-9.731e-02    prwg=1.4770e-01     cit=0.0000e+00 \
tox=8.1000e-09 \
  ngate=0.0000e+00 \
    nlx=1.7700e-07 \
     xl=4.0000e-08      xw=-7.000e-08 \
     af=1.4050e+00      kf=1.8270e-26      ef=1.0000e+00 \
   noia=7.0910e+18    noib=6.0740e+04    noic=3.7790e-13 \
     rd=0.0000e+00      rs=0.0000e+00     rsh=1.6000e+02 \
   minr=1.000e-03 \
    rdc=0.0000e+00     rsc=0.0000e+00 lint=-7.130e-08 \
wint=3.4490e-08   ldif=0.000e+00    hdif=8.0000e-07 \
     xj=3.0000e-07      js=2.8000e-07 \
      n=1.0000e+00 \
  dskip=no          tlev=0           tlevc=0         \
    jsw=3.7000e-13 \
     cj=1.5230e-03    cjsw=3.5800e-10 \
     fc=0.0000e+00    fcsw=0.000e+00 \
     mj=5.4000e-01    mjsw=4.6000e-01 \
     pb=1.0200e+00    pbsw=1.0200e+00     xti=1.9730e+00
ends modp

// ----------------------------------------------------------------------

// ----------------------------------------------------------------------
// Owner: austriamicrosystems
// HIT-Kit: Digital
// ************************ SIMULATION PARAMETERS ************************
//  ----------------------------------------------------------------------
//  format    : Spectre (Spectre Direct)
//  model     : MOS BSIM3v3
//  process   : C35
//  revision  : 5.0;
//  extracted : B27167L1W5C45; 15-04-2007; bse (5866)
//  doc#      : Eng-182 REV_6
//  ----------------------------------------------------------------------
//                         WORST CASE SPEED CONDITION
//
//  ----------------------------------------------------------------------
//
inline subckt modpl ( d g s b )
parameters w=1.0e-6 l=1.0e-6 nrd=0.0 nrs=0.0 ad=0.0 as=0.0 pd=0.0 ps=0.0 ng=1
+ ws= w
+ ls= l
+ shk=1
+ dvthmat=(mv_modpl)*(1.24e-08/sqrt(ls*ws*ng)) dumat=(mu_modpl)*(5.7e-9/sqrt(ls*ws*ng))
//
if (modpl==1)
modpl ( d g s b ) mosinsub w=ws l=ls nrd=8.0000e-07/ws nrs=8.0000e-07/ws ad=ad as=as pd=pd ps=ps m=ng
else
modpl ( d s ) resistor r=1e30
notvalid paramtest errorif=(modpl==0) \
message="
***************************************************
*
* pmosl is not valid in selected process option.
*
***************************************************"
model mosinsub bsim3v3 version=3.2400e+00  type=p  capmod=2.0000e+00 \
 mobmod=1.0000e+00  nqsmod=0.0000e+00  noimod=3.0000e+00 \
   vbox=1.000e+03      k1=6.8800e-01 \
     k2=-7.790e-02      k3=5.2610e+01     k3b=7.2440e+00 \
    nch=9.4750e+16 vth0=-6.040e-01+dvthmat \
   voff=-2.280e-01    dvt0=1.0460e+00    dvt1=3.9190e-01 \
   dvt2=1.9100e-03    keta=-2.400e-03 \
 pscbe1=1.0000e+30  pscbe2=1.0000e-06 \
 alpha0=1.1750e-08  alpha1=1.0000e-03   beta0=1.9580e+01 \
  dvt0w=1.0000e+00   dvt1w=5.3000e+06   dvt2w=9.5620e-02 \
     ua=1.0000e-12      ub=1.9050e-18      uc=6.3100e-11 \
u0=1.2950e+02+(1.2950e+02)*dumat \
   dsub=5.0000e-01    eta0=1.9590e-01    etab=0.0000e+00 \
nfactor=1.5790e+00 \
     em=4.1000e+07    pclm=8.2410e-01 \
  drout=5.0000e-01 \
     a0=5.0000e-01      a1=0.0000e+00      a2=1.0000e+00 \
   pvag=0.0000e+00    vsat=9.8190e+04     ags=2.6300e-01      b0=6.0600e-08      b1=0.0000e+00 \
  delta=4.3330e-03 pdiblcb=9.6330e-01 \
pdiblc1=1.0000e-03 pdiblc2=1.3800e-03 \
     w0=1.9050e-06 \
    dlc=2.0000e-08 \
    dwc=7.2920e-08     dwb=1.6220e-08     dwg=0.0000e+00 \
     ll=0.0000e+00      lw=0.0000e+00     lwl=0.0000e+00 \
    lln=1.0000e+00     lwn=1.0000e+00      wl=0.0000e+00 \
     ww=-2.000e-14     wwl=0.0000e+00     wln=1.0000e+00 \
     wr=1.0000e+00     wwn=1.0400e+00 \
     at=3.3000e+04     ute=-1.280e+00 \
    kt1=-5.577e-01     kt2=-6.560e-02    kt1l=0.0000e+00 \
    ua1=0.0000e+00     ub1=0.0000e+00     uc1=0.0000e+00 \
    prt=0.0000e+00 \
   cgso=5.6000e-11    cgdo=5.6000e-11    cgbo=1.2000e-10 \
   cgdl=2.7000e-10    cgsl=2.7000e-10  ckappa=5.6400e-01 \
     cf=0.0000e+00     elm=5.0000e+00 \
  xpart=1.0000e+00     clc=1.0000e-15     cle=6.0000e-01 \
\
   rdsw=2.0890e+03 \
   cdsc=1.3750e-03   cdscb=4.4880e-04   cdscd=1.9130e-04 \
   prwb=3.8020e-02    prwg=-1.047e-01     cit=0.0000e+00 \
tox=8.1000e-09 \
  ngate=1.0000e+00 \
    nlx=1.6220e-07 \
     xl=1.0000e-07      xw=0.0000e+00 \
     af=1.4690e+00      kf=1.2960e-26      ef=1.0000e+00 \
   noia=2.9220e+19    noib=1.7730e+04    noic=4.5200e-13 \
     rd=0.0000e+00      rs=0.0000e+00     rsh=1.6500e+02 \
   minr=1.000e-03 \
    rdc=0.0000e+00     rsc=0.0000e+00 lint=-1.285e-08 \
wint=7.2920e-08   ldif=0.000e+00    hdif=8.0000e-07 \
     xj=3.0000e-07      js=2.8000e-07 \
      n=1.0000e+00 \
  dskip=no          tlev=0           tlevc=0         \
    jsw=3.7000e-13 \
     cj=1.6320e-03    cjsw=4.2000e-10 \
     fc=0.0000e+00    fcsw=0.000e+00 \
     mj=5.4000e-01    mjsw=4.6000e-01 \
     pb=1.0200e+00    pbsw=1.0200e+00     xti=1.9700e+00
ends modpl

// ----------------------------------------------------------------------
//----------------------------------------------------------------------
//************************* SIMULATION PARAMETERS ************************
// ----------------------------------------------------------------------
// format    : Spectre ( Spectre Direct )
// model     : DIODE
// process   : C35
// revision  : 4.1;
// extracted : C64685 ; 2002-12; ese(5487)
// doc#      : ENG-182 REV_6
// ----------------------------------------------------------------------
//                       WORST CASE SPEED CONDITION
// ----------------------------------------------------------------------
// TERMINALS: A=anode=P-region C=cathode=N-region
// VARIABLES: M (mulitiplier), AREA [m^2], PERI [m].
// NOTE: The role of a protection DIODE is to conduct ESD current to VDD
// (or from VSS). This forward bias is NOT modelled, only leakage current
// and capacitance during normal operation. Any inductive load etc that
// will give forward bias, must be limited by other components to within
// Operating Conditions, otherwise parasitic bipolar action can occur.
//
// Parameters: area perim
//
inline subckt pd ( a c )
parameters area=1.0e-12 perimeter=1.0e-6
//
if (welldiode==1)
pd ( a c ) diodeinsub area=area perim=perimeter region=off
else
pd ( a c ) resistor r=1e30
notvalid paramtest errorif=(welldiode==0) \
message="
***************************************************
*
* welldiode is not valid in selected process option.
*
***************************************************"
model diodeinsub diode level=1 dskip=no \
     is=2.8000e-07     isw=3.7000e-13       n=1.0000e+00      ns=1.0000e+00 \
   minr=0.100e+00    imax=(1.000e+00/area) \
    cjo=1.5230e-03       m=5.4000e-01      vj=1.0200e+00      tt=0.000e+00 \
    xti=1.9730e+00 \
   cjsw=3.5800e-10    mjsw=4.6000e-01    vjsw=1.0200e+00      fc=0.000e+00 \
     af=1.000e+00      kf=0.000e+00
ends pd
// ----------------------------------------------------------------------
// Owner: austriamicrosystems
// HIT-Kit: Digital
// ************************ SIMULATION PARAMETERS ************************
//  ----------------------------------------------------------------------
//  format    : Spectre (Spectre Direct)
//  model     : MOS BSIM3v3
//  process   : C35
//  revision  : 4.1;
//  extracted : C35 B11004.L2; 2002-11; hhl(5481)
//  doc#      : Eng-182  REV_6.0
//  ----------------------------------------------------------------------
//                        WORST CASE SPEED CONDITION
//  ----------------------------------------------------------------------
//  HV-TRANSISTOR
//  ----------------------------------------------------------------------
inline subckt modnmh ( d g s b )
// Parameters: w l nrd nrs ad as pd ps
parameters w=1.0e-6 l=1.0e-6 nrd=0.0 nrs=0.0 ad=0.0 as=0.0 pd=0.0 ps=0.0 mult=1
+ ws=w
+ ls=l
+ dvthmat=mv_modnmh*(1.03e-08/sqrt(ls*ws*mult)) dumat=mu_modnmh*(3.5e-9/sqrt(ls*ws*mult))
//
if (modnmh==1){
modnmh ( d1 g s b ) mosinsub w=ws l=ls nrd=0 nrs=6.0000e-07/ws ad=ad as=as pd=pd ps=ps
rd ( d1 d ) resistor r=(1.9340e+03*4.0000e-06/(ws)) tc1=6.2000e-03
}else
modnmh ( d s ) resistor r=1e30
notvalid paramtest errorif=(modnmh==0) \
message="
***************************************************
*
* nmosmh is not valid in selected process option.
*
***************************************************"
//
model mosinsub bsim3v3 version=3.1 type=n  capmod=2.0000e+00 \
 mobmod=1.0000e+00  nqsmod=0.0000e+00  noimod=3 \
   vbox=1.000e+03      k1=1.1431e+00 \
     k2=4.0073e-02      k3=-2.439e+00     k3b=4.0770e-01 \
    nch=2.4110e+17 vth0=7.5490e-01+dvthmat \
   voff=-4.948e-02    dvt0=4.9850e+01    dvt1=1.6830e+00 \
   dvt2=4.1260e-02    keta=-7.397e-02 \
 pscbe1=4.0000e+10  pscbe2=1.0000e-10 \
 alpha0=0.0000e+00   beta0=3.0000e+01 \
  dvt0w=0.0000e+00   dvt1w=0.0000e+00   dvt2w=0.0000e+00 \
     ua=1.0000e-12      ub=3.7680e-19      uc=6.3910e-12 \
u0=3.7650e+02+(3.7650e+02)*dumat \
   dsub=5.0000e-01    eta0=1.6160e-03    etab=-1.373e-02 \
nfactor=3.4550e-01 \
     em=4.1000e+07    pclm=1.0550e-01 \
  drout=5.0000e-01 \
     a0=2.1900e-01      a1=0.0000e+00      a2=1.0000e+00 \
   pvag=0.0000e+00    vsat=5.1290e+04     ags=9.4480e-02      b0=-3.629e-08      b1=0.0000e+00 \
  delta=3.3700e-03 pdiblcb=3.8720e-01 \
pdiblc1=1.0000e-10 pdiblc2=1.0000e-10 \
     w0=6.2890e-08 \
    dlc=8.9170e-08 \
    dwc=4.9380e-08     dwb=0.0000e+00     dwg=0.0000e+00 \
     ll=0.0000e+00      lw=0.0000e+00     lwl=0.0000e+00 \
    lln=1.0000e+00     lwn=1.0000e+00      wl=0.0000e+00 \
     ww=0.0000e+00     wwl=0.0000e+00     wln=1.0000e+00 \
    wwn=1.0000e+00 \
   tnom=2.7000e+01      at=3.3000e+04     ute=-1.760e+00 \
    kt1=-4.502e-01     kt2=2.2000e-02    kt1l=0.0000e+00 \
    ua1=0.0000e+00     ub1=0.0000e+00     uc1=0.0000e+00 \
    prt=0.0000e+00 \
   cgso=1.2100e-10    cgdo=1.2100e-10    cgbo=1.2000e-10 \
   cgdl=0.0000e+00    cgsl=0.0000e+00  ckappa=6.0000e-01 \
     cf=0.0000e+00     elm=5.0000e+00 \
  xpart=1.0000e+00     clc=1.0000e-15     cle=6.0000e-01 \
\
   rdsw=5.3040e+02 \
   cdsc=1.0000e-02   cdscb=0.0000e+00   cdscd=8.4480e-05 \
   prwb=0.0000e+00    prwg=0.0000e+00     cit=8.1220e-04 \
tox=1.6000e-08 \
  ngate=0.0000e+00 \
    nlx=1.5930e-07 \
     xl=-1.050e-06      xw=-2.000e-07 \
     af=1.3580e+00      kf=3.4460e-26      ef=1.0000e+00 \
   noia=1.7020e+20    noib=5.4630e+05    noic=-1.400e-11 \
     rd=0.0000e+00      rs=0.0000e+00     rsh=8.5000e+01 \
   minr=1.000e-03 \
    rdc=0.0000e+00     rsc=0.0000e+00 lint=8.9170e-08 \
wint=4.9380e-08   ldif=0.000e+00    hdif=6.0000e-07 \
     xj=3.0000e-07      js=5.1000e-07 \
      n=1.0000e+00 \
  dskip=no          tlev=0           tlevc=0         \
    jsw=6.0000e-13 \
     cj=1.0000e-04    cjsw=6.3750e-10 \
     fc=0.0000e+00    fcsw=0.000e+00 \
     mj=3.9000e-01    mjsw=2.7000e-01 \
     pb=5.3000e-01    pbsw=6.9000e-01     xti=2.0260e+00
ends modnmh
// ----------------------------------------------------------------------
// Owner: austriamicrosystems
// HIT-Kit: Digital
// ************************ SIMULATION PARAMETERS ************************
//  ----------------------------------------------------------------------
//  format    : Spectre (Spectre Direct)
//  model     : MOS BSIM3v3
//  process   : c35
//  revision  : 4.1;
//  extracted : Wafer B26654W01 2005/10/10 REVISION 4.0; wpc(5481)
//  doc#      : Eng-182  REV 6.0
//  ----------------------------------------------------------------------
//                        WORST CASE SPEED CONDITION
//  ----------------------------------------------------------------------
//  HV-TRANSISTOR
//  ----------------------------------------------------------------------
inline subckt modnmhl ( d g s b )
// Parameters: w l nrd nrs ad as pd ps
parameters w=1.0e-6 l=1.0e-6 nrd=0.0 nrs=0.0 ad=0.0 as=0.0 pd=0.0 ps=0.0 mult=1
+ ws=w
+ ls=l
+ dvthmat=mv_modnmhl*(0.95e-08/sqrt(ls*ws*mult)) dumat=mu_modnmhl*(3.5e-9/sqrt(ls*ws*mult))
//
if (modnmhl==1){
modnmhl ( d1 g s b ) mosinsub w=ws l=ls nrd=0 nrs=8.0000e-07/ws ad=ad as=as pd=pd ps=ps
rd ( d1 d ) resistor r=(2.1840e+03*4.0000e-06/(ws+(0.0000e+00))) tc1=6.2000e-03
}else
modnmhl ( d s ) resistor r=1e30
notvalid paramtest errorif=(modnmhl==0) \
message="
***************************************************
*
* nmosmhl is not valid in selected process option.
*
***************************************************"
//
model mosinsub bsim3v3 version=3.1 type=n  capmod=2.0000e+00 \
 mobmod=1.0000e+00  nqsmod=0.0000e+00  noimod=3 \
   vbox=1.000e+03      k1=7.9503e-01 \
     k2=8.4613e-02      k3=0.0000e+00     k3b=0.0000e+00 \
    nch=1.7070e+17 vth0=5.9500e-01+dvthmat \
   voff=-5.565e-02    dvt0=0.0000e+00    dvt1=1.6830e+00 \
   dvt2=4.1260e-02    keta=-8.210e-02 \
 pscbe1=4.0000e+10  pscbe2=1.0000e-10 \
 alpha0=0.0000e+00   beta0=3.0000e+01 \
  dvt0w=0.0000e+00   dvt1w=0.0000e+00   dvt2w=0.0000e+00 \
     ua=2.2380e-10      ub=0.0000e+00      uc=-1.429e-11 \
u0=4.0780e+02+(4.0780e+02)*dumat \
   dsub=5.0000e-01    eta0=1.6160e-03    etab=-1.373e-02 \
nfactor=8.5500e-01 \
     em=4.1000e+07    pclm=1.0550e-01 \
  drout=5.0000e-01 \
     a0=4.7540e-02      a1=0.0000e+00      a2=1.0000e+00 \
   pvag=0.0000e+00    vsat=5.2060e+04     ags=-3.227e-01      b0=0.0000e+00      b1=0.0000e+00 \
  delta=1.5850e-02 pdiblcb=3.8720e-01 \
pdiblc1=1.0000e-10 pdiblc2=1.0000e-10 \
     w0=0.0000e+00 \
    dlc=0.0000e+00 \
    dwc=0.0000e+00     dwb=0.0000e+00     dwg=0.0000e+00 \
     ll=0.0000e+00      lw=0.0000e+00     lwl=0.0000e+00 \
    lln=1.0000e+00     lwn=1.0000e+00      wl=0.0000e+00 \
     ww=0.0000e+00     wwl=0.0000e+00     wln=1.0000e+00 \
    wwn=1.0000e+00 \
     at=3.3000e+04     ute=-1.720e+00 \
    kt1=-4.202e-01     kt2=2.2000e-02    kt1l=0.0000e+00 \
    ua1=0.0000e+00     ub1=0.0000e+00     uc1=0.0000e+00 \
    prt=0.0000e+00 \
   cgso=1.2000e-10    cgdo=1.2000e-10    cgbo=1.2000e-10 \
   cgdl=0.0000e+00    cgsl=0.0000e+00  ckappa=6.0000e-01 \
     cf=0.0000e+00     elm=5.0000e+00 \
  xpart=1.0000e+00     clc=1.0000e-15     cle=6.0000e-01 \
\
   rdsw=5.3040e+02 \
   cdsc=0.0000e+00   cdscb=0.0000e+00   cdscd=0.0000e+00 \
   prwb=0.0000e+00    prwg=0.0000e+00     cit=2.9310e-05 \
tox=1.6400e-08 \
  ngate=0.0000e+00 \
    nlx=1.5930e-07 \
     xl=1.0000e-07      xw=-1.500e-07 \
     af=1.4000e+00      kf=3.7700e-26      ef=1.0000e+00 \
   noia=1.5360e+20    noib=3.5840e+05    noic=-1.304e-11 \
     rd=0.0000e+00      rs=0.0000e+00     rsh=7.5000e+01 \
   minr=1.000e-03 \
    rdc=0.0000e+00     rsc=0.0000e+00 lint=6.0000e-07 \
wint=0.0000e+00   ldif=0.000e+00    hdif=8.0000e-07 \
     xj=3.0000e-07      js=5.1000e-07 \
      n=1.0000e+00 \
  dskip=no          tlev=0           tlevc=0         \
    jsw=6.0000e-13 \
     cj=1.0380e-03    cjsw=3.1250e-10 \
     fc=0.0000e+00    fcsw=0.000e+00 \
     mj=3.4000e-01    mjsw=2.3000e-01 \
     pb=6.9000e-01    pbsw=6.9000e-01     xti=2.0300e+00
ends modnmhl
// ----------------------------------------------------------------------
// Owner: austriamicrosystems
// HIT-Kit: Digital
// ************************ SIMULATION PARAMETERS ************************
//  ----------------------------------------------------------------------
//  format    : Spectre (Spectre Direct)
//  model     : MOS BSIM3v3
//  process   : C35
//  revision  : 4.1;
//  extracted : C35 B11004.L2; 2002-11; hhl(5481)
//  doc#      : Eng-182  REV_6.0
//  ----------------------------------------------------------------------
//                        WORST CASE SPEED CONDITION
//  ----------------------------------------------------------------------
//  HV-TRANSISTOR
//  ----------------------------------------------------------------------
inline subckt modnh ( d g s b )
// Parameters: w l nrd nrs ad as pd ps
parameters w=1.0e-6 l=1.0e-6 nrd=0.0 nrs=0.0 ad=0.0 as=0.0 pd=0.0 ps=0.0 mult=1
+ ws=w
+ ls=l
+ dvthmat=mv_modnh*(0.67e-08/sqrt(ls*ws*mult)) dumat=mu_modnh*(4.9e-9/sqrt(ls*ws*mult))
//
if (modnh==1){
modnh ( d1 g s b ) mosinsub w=ws l=ls nrd=0 nrs=6.0000e-07/ws ad=ad as=as pd=pd ps=ps
rd ( d1 d ) resistor r=(1.6600e+03*4.0000e-06/(ws)) tc1=6.2000e-03
}else
modnh ( d s ) resistor r=1e30
notvalid paramtest errorif=(modnh==0) \
message="
***************************************************
*
* nmosh is not valid in selected process option.
*
***************************************************"
//
model mosinsub bsim3v3 version=3.1 type=n  capmod=2.0000e+00 \
 mobmod=1.0000e+00  nqsmod=0.0000e+00  noimod=3 \
   vbox=1.000e+03      k1=7.8029e-01 \
     k2=-1.846e-02      k3=-2.240e+00     k3b=6.9540e-01 \
    nch=2.7130e+17 vth0=5.3600e-01+dvthmat \
   voff=-5.090e-02    dvt0=4.9850e+01    dvt1=1.2960e+00 \
   dvt2=1.3110e-02    keta=-4.553e-02 \
 pscbe1=1.0000e+10  pscbe2=1.0240e-05 \
 alpha0=0.0000e+00   beta0=3.0000e+01 \
  dvt0w=0.0000e+00   dvt1w=0.0000e+00   dvt2w=0.0000e+00 \
     ua=1.0000e-30      ub=1.9490e-18      uc=1.2170e-10 \
u0=3.3870e+02+(3.3870e+02)*dumat \
   dsub=5.0000e-01    eta0=3.0750e-02    etab=-5.261e-02 \
nfactor=2.0340e-01 \
     em=4.1000e+07    pclm=2.9400e-01 \
  drout=5.0000e-01 \
     a0=1.8930e-01      a1=0.0000e+00      a2=1.0000e+00 \
   pvag=0.0000e+00    vsat=2.4020e+05     ags=1.2450e-01      b0=6.7900e-08      b1=0.0000e+00 \
  delta=1.7290e-02 pdiblcb=2.0670e-01 \
pdiblc1=3.0900e-02 pdiblc2=6.3750e-04 \
     w0=1.1450e-07 \
    dlc=6.0000e-07 \
    dwc=2.6050e-08     dwb=0.0000e+00     dwg=0.0000e+00 \
     ll=0.0000e+00      lw=0.0000e+00     lwl=0.0000e+00 \
    lln=1.0000e+00     lwn=1.0000e+00      wl=0.0000e+00 \
     ww=0.0000e+00     wwl=0.0000e+00     wln=1.0000e+00 \
    wwn=1.0000e+00 \
   tnom=2.7000e+01      at=3.3000e+04     ute=-1.800e+00 \
    kt1=-3.302e-01     kt2=2.2000e-02    kt1l=0.0000e+00 \
    ua1=0.0000e+00     ub1=0.0000e+00     uc1=0.0000e+00 \
    prt=0.0000e+00 \
   cgso=1.3400e-10    cgdo=1.3400e-10    cgbo=1.2000e-10 \
   cgdl=0.0000e+00    cgsl=0.0000e+00  ckappa=6.0000e-01 \
     cf=0.0000e+00     elm=5.0000e+00 \
  xpart=1.0000e+00     clc=1.0000e-15     cle=6.0000e-01 \
\
   rdsw=1.0920e+03 \
   cdsc=7.9440e-03   cdscb=0.0000e+00   cdscd=8.4480e-05 \
   prwb=0.0000e+00    prwg=0.0000e+00     cit=1.0000e-03 \
tox=8.1000e-09 \
  ngate=0.0000e+00 \
    nlx=1.1320e-07 \
     xl=0.0000e+00      xw=-2.000e-07 \
     af=1.3580e+00      kf=3.4460e-26      ef=1.0000e+00 \
   noia=1.7020e+20    noib=5.4630e+05    noic=-1.400e-11 \
     rd=0.0000e+00      rs=0.0000e+00     rsh=8.5000e+01 \
   minr=1.000e-03 \
    rdc=0.0000e+00     rsc=0.0000e+00 lint=6.0000e-07 \
wint=2.6050e-08   ldif=0.000e+00    hdif=6.0000e-07 \
     xj=3.0000e-07      js=5.1000e-07 \
      n=1.0000e+00 \
  dskip=no          tlev=0           tlevc=0         \
    jsw=6.0000e-13 \
     cj=1.0000e-04    cjsw=6.3750e-10 \
     fc=0.0000e+00    fcsw=0.000e+00 \
     mj=3.9000e-01    mjsw=2.7000e-01 \
     pb=5.3000e-01    pbsw=6.9000e-01     xti=2.0260e+00
ends modnh
// ----------------------------------------------------------------------
// Owner: austriamicrosystems
// HIT-Kit: Digital
// ************************ SIMULATION PARAMETERS ************************
//  ----------------------------------------------------------------------
//  format    : Spectre (Spectre Direct)
//  model     : MOS BSIM3v3
//  process   : c35
//  revision  : 4.0;
//  extracted : Wafer B26654W01 2005/10/05 REVISION 4.0; wpc(5481)
//  doc#      : Eng-182  REV 6.0
//  ----------------------------------------------------------------------
//                        WORST CASE SPEED CONDITION
//  ----------------------------------------------------------------------
//  HV-TRANSISTOR
//  ----------------------------------------------------------------------
inline subckt modnhl ( d g s b )
// Parameters: w l nrd nrs ad as pd ps
parameters w=1.0e-6 l=1.0e-6 nrd=0.0 nrs=0.0 ad=0.0 as=0.0 pd=0.0 ps=0.0 mult=1
+ ws=w
+ ls=l
+ dvthmat=mv_modnhl*(0.67e-08/sqrt(ls*ws*mult)) dumat=mu_modnhl*(4.9e-9/sqrt(ls*ws*mult))
//
if (modnhl==1){
modnhl ( d1 g s b ) mosinsub w=ws l=ls nrd=0 nrs=8.0000e-07/ws ad=ad as=as pd=pd ps=ps
rd ( d1 d ) resistor r=(1.7600e+03*4.0000e-06/(ws+(0.0000e+00))) tc1=6.2000e-03
}else
modnhl ( d s ) resistor r=1e30
notvalid paramtest errorif=(modnhl==0) \
message="
***************************************************
*
* nmoshl is not valid in selected process option.
*
***************************************************"
//
model mosinsub bsim3v3 version=3.1 type=n  capmod=2.0000e+00 \
 mobmod=1.0000e+00  nqsmod=0.0000e+00  noimod=3 \
   vbox=1.000e+03      k1=5.8829e-01 \
     k2=3.3954e-03      k3=0.0000e+00     k3b=0.0000e+00 \
    nch=1.9900e+17 vth0=4.6560e-01+dvthmat \
   voff=-5.119e-02    dvt0=0.0000e+00    dvt1=1.2960e+00 \
   dvt2=1.3110e-02    keta=-3.955e-02 \
 pscbe1=1.0000e+10  pscbe2=1.0240e-05 \
 alpha0=0.0000e+00   beta0=3.0000e+01 \
  dvt0w=0.0000e+00   dvt1w=0.0000e+00   dvt2w=0.0000e+00 \
     ua=1.0000e-30      ub=1.9490e-18      uc=1.2170e-10 \
u0=3.1630e+02+(3.1630e+02)*dumat \
   dsub=5.0000e-01    eta0=0.0000e+00    etab=0.0000e+00 \
nfactor=1.1530e+00 \
     em=4.1000e+07    pclm=2.9400e-01 \
  drout=5.0000e-01 \
     a0=3.3100e-01      a1=0.0000e+00      a2=1.0000e+00 \
   pvag=0.0000e+00    vsat=2.4020e+06     ags=3.2310e-01      b0=0.0000e+00      b1=0.0000e+00 \
  delta=3.1850e-02 pdiblcb=2.0670e-04 \
pdiblc1=3.0900e-02 pdiblc2=6.3750e-04 \
     w0=1.1450e-07 \
    dlc=0.0000e+00 \
    dwc=0.0000e+00     dwb=0.0000e+00     dwg=0.0000e+00 \
     ll=0.0000e+00      lw=0.0000e+00     lwl=0.0000e+00 \
    lln=1.0000e+00     lwn=1.0000e+00      wl=0.0000e+00 \
     ww=0.0000e+00     wwl=0.0000e+00     wln=1.0000e+00 \
    wwn=1.0000e+00 \
     at=3.3000e+04     ute=-1.700e+00 \
    kt1=-3.001e-01     kt2=2.2000e-02    kt1l=0.0000e+00 \
    ua1=0.0000e+00     ub1=0.0000e+00     uc1=0.0000e+00 \
    prt=0.0000e+00 \
   cgso=1.3400e-10    cgdo=1.3400e-10    cgbo=1.2000e-10 \
   cgdl=0.0000e+00    cgsl=0.0000e+00  ckappa=6.0000e-01 \
     cf=0.0000e+00     elm=5.0000e+00 \
  xpart=1.0000e+00     clc=1.0000e-15     cle=6.0000e-01 \
\
   rdsw=1.0920e+03 \
   cdsc=0.0000e+00   cdscb=0.0000e+00   cdscd=0.0000e+00 \
   prwb=0.0000e+00    prwg=0.0000e+00     cit=-2.050e-04 \
tox=8.1000e-09 \
  ngate=0.0000e+00 \
    nlx=1.1320e-07 \
     xl=2.5000e-07      xw=-1.500e-07 \
     af=1.4000e+00      kf=3.7700e-26      ef=1.0000e+00 \
   noia=1.5360e+20    noib=3.5840e+05    noic=-1.304e-11 \
     rd=0.0000e+00      rs=0.0000e+00     rsh=7.5000e+01 \
   minr=1.000e-03 \
    rdc=0.0000e+00     rsc=0.0000e+00 lint=6.0000e-07 \
wint=0.0000e+00   ldif=0.000e+00    hdif=8.0000e-07 \
     xj=3.0000e-07      js=5.1000e-07 \
      n=1.0000e+00 \
  dskip=no          tlev=0           tlevc=0         \
    jsw=6.0000e-13 \
     cj=1.0380e-03    cjsw=3.1250e-10 \
     fc=0.0000e+00    fcsw=0.000e+00 \
     mj=3.4000e-01    mjsw=2.3000e-01 \
     pb=6.9000e-01    pbsw=6.9000e-01     xti=2.0300e+00
ends modnhl
// ----------------------------------------------------------------------
// Owner: austriamicrosystems
// HIT-Kit: Digital
// ************************ SIMULATION PARAMETERS ************************
//  ----------------------------------------------------------------------
//  format    : Spectre (Spectre Direct)
//  model     : MOS BSIM3v3
//  process   : c35
//  revision  : ;
//  extracted : B58737.W09PE6; 2008-06; kmo(5966)
//  doc#      : ENG-327 Rev.2.0
//  ----------------------------------------------------------------------
//                        WORST CASE SPEED CONDITION
//  ----------------------------------------------------------------------
//  HV-TRANSISTOR
//  ----------------------------------------------------------------------
inline subckt modn30m ( d g s b )
// Parameters: w l nrd nrs ad as pd ps
parameters w=1.0e-6 l=1.0e-6 nrd=0.0 nrs=0.0 ad=0.0 as=0.0 pd=0.0 ps=0.0 mult=1 gv=(7.6860e-08/l + 9.1600e-01) dcdc=1
+ dvthmat=mv_modn30m*(0.56e-08/sqrt(l*w*mult)) dumat=mu_modn30m*(2.9e-9/sqrt(l*w*mult))
if (modn30m==1){
//
modn30m ( d1 g s1 b ) mosinsub w=w l=l nrd=0 nrs=8.0000e-07/w ad=0 as=as pd=0 ps=ps
rd ( d1 d ) resistor r=(1.1020e+00/(w+(1.6670e-06))) tc1=6.0000e-03
xj1 ( d gj d1 ) modn30mjfet1 w=w
xj2 ( d gj d1 ) modn30mjfet2 w=w
e1 ( d1 gj d1 s ) vcvs gain=gv min=-25 max=25
cgdx ( g d ) capacitor c=(4.2900e-10*w)
v1 ( s1 s ) vsource dc=0 type=dc
i1 ( d b ) bsource i=((6.1450e-10)/(l+(0.0000e+00))+(6.1590e-03))*i("v1:p")*(max((v(d,g)+(1.8290e-02)),1e-15))**(4.1480e+00)*exp((-1.4550e+01)/max((v(d,g)+(1.8290e-02)),1e-10))*(w+0.0000e+00)/w/(1+2.8000e+04*exp(7.7390e-03*i("v1:p")/(w+0.0000e+00)))
xdw ( b d1 ) modn30mnwd area=(1e-06*2.35*(w+1e-06*16)) perimeter=(4e-06*2.35+(w+1e-06*16))
}else
modn30m ( d s ) resistor r=1e30
notvalid paramtest errorif=(modn30m==0) \
message="
***************************************************
*
* nmos30m is not valid in selected process option.
*
***************************************************"
//
model mosinsub bsim3v3 version=3.1 type=n  capmod=2.0000e+00 \
 mobmod=1.0000e+00  nqsmod=0.0000e+00  noimod=3.0000e+00 \
   vbox=1.000e+03      k1=1.0212e+00 \
     k2=7.8677e-02      k3=2.3030e-01     k3b=-1.516e-02 \
    nch=2.5610e+17 vth0=8.0770e-01+dvthmat \
   voff=-6.529e-02    dvt0=1.1390e-03    dvt1=1.0310e-01 \
   dvt2=-1.601e-01    keta=-1.236e-02 \
 pscbe1=3.5770e+12  pscbe2=5.7730e-12 \
 alpha0=0.0000e+00   beta0=3.0000e+01 \
  dvt0w=3.0490e-01   dvt1w=2.3530e+05   dvt2w=-2.685e+00 \
     ua=5.6220e-12      ub=9.5730e-19      uc=7.1200e-13 \
u0=3.7000e+02+(3.7000e+02)*dumat \
   dsub=5.2500e+00    eta0=1.0000e-07    etab=-3.000e-01 \
nfactor=9.0620e-01 \
     em=4.1000e+07    pclm=2.8550e+00 \
  drout=5.0000e-01 \
     a0=8.2080e-01      a1=0.0000e+00      a2=1.0000e+00 \
   pvag=0.0000e+00    vsat=8.9380e+04     ags=1.8620e-02      b0=3.0590e-09      b1=2.6720e-02 \
  delta=3.7770e-05 pdiblcb=1.0000e-12 \
pdiblc1=5.1750e-04 pdiblc2=3.7770e-07 \
     w0=-4.630e-06 \
    dlc=-7.500e-07 \
    dwc=2.7390e-07     dwb=0.0000e+00     dwg=0.0000e+00 \
     ll=0.0000e+00      lw=0.0000e+00     lwl=0.0000e+00 \
    lln=1.0000e+00     lwn=1.0000e+00      wl=0.0000e+00 \
     ww=0.0000e+00     wwl=0.0000e+00     wln=1.0000e+00 \
    wwn=1.0000e+00 \
     at=3.3000e+04     ute=-1.710e+00 \
    kt1=-4.600e-01     kt2=2.2000e-02    kt1l=0.0000e+00 \
    ua1=0.0000e+00     ub1=0.0000e+00     uc1=0.0000e+00 \
    prt=0.0000e+00 \
   cgso=1.2852e-10    cgdo=1.0000e-15    cgbo=1.3200e-10 \
   cgdl=5.0000e-10    cgsl=4.8800e-10  ckappa=1.9890e+00 \
     cf=0.0000e+00     elm=5.0000e+00 \
  xpart=5.0000e-01     clc=1.0000e-15     cle=6.0000e-01 \
\
   rdsw=0.0000e+00 \
   cdsc=1.9360e-06   cdscb=1.0000e-12   cdscd=1.0740e-08 \
   prwb=0.0000e+00    prwg=0.0000e+00     cit=1.0740e-06 \
tox=1.6000e-08 \
  ngate=0.0000e+00 \
    nlx=2.6040e-07 \
     xl=0.0000e+00      xw=0.0000e+00 \
     af=1.9886e+00      kf=1.6086e-24      ef=1.0000e+00 \
   noia=2.5794e+19    noib=1.0199e+05    noic=-2.372e-12 \
     rd=0.0000e+00      rs=0.0000e+00     rsh=7.5000e+01 \
   minr=1.000e-03 \
    rdc=0.0000e+00     rsc=0.0000e+00 lint=-2.271e-07 \
wint=2.7390e-07   ldif=0.000e+00    hdif=8.0000e-07 \
     xj=9.0000e-07      js=3.5530e-07 \
      n=1.0000e+00 \
  dskip=no          tlev=0           tlevc=0         \
    jsw=1.7560e-12 \
     cj=1.0500e-03    cjsw=3.1250e-10 \
     fc=0.0000e+00    fcsw=0.000e+00 \
     mj=3.4000e-01    mjsw=2.3000e-01 \
     pb=6.9000e-01    pbsw=6.9000e-01     xti=2.0260e+00
ends modn30m
// HV-jfet 1
inline subckt modn30mjfet1 (d b s)
parameters w=1e-6
modn30mjfet1 (d b s) rnjfetinsub
model rnjfetinsub jfet type=n \
beta=3.9830e+00/(1+(2.8000e-03)*(temp-(2.7000e+01)))*(w+(1.6670e-06))/(1+(6.0000e-03)*(temp-27)) \
vto=-5.700e+00*(1+(2.8000e-03)*(temp-(2.7000e+01))) \
lambda=0.0000e+00 \
is=0.0000e+00  pb=5.0000e-01 \
cgs=0.0000e+00 rs=0.0000e+00 \
cgd=0.0000e+00 rd=0.0000e+00
ends modn30mjfet1
// HV-jfet 2
inline subckt  modn30mjfet2 (d b s)
parameters w=1e-6
modn30mjfet2 (d b s) rnjfetinsub
model rnjfetinsub jfet type=n \
beta=4.0450e+00/(1+(2.8000e-03)*(temp-(2.7000e+01)))*(w+(1.6670e-06))/(1+(6.0000e-03)*(temp-27)) \
vto=-7.957e+00*(1+(2.8000e-03)*(temp-(2.7000e+01))) \
lambda=0.0000e+00 \
is=0.0000e+00  pb=5.0000e-01 \
cgs=0.0000e+00 rs=0.0000e+00 \
cgd=0.0000e+00 rd=0.0000e+00
ends modn30mjfet2
//

inline subckt modn30mnwd ( a c )
parameters area=1.0e-12 perimeter=1.0e-6
modn30mnwd ( a c ) diodeinsub area=area perim=perimeter region=off
model diodeinsub diode level=1 dskip=no \
is=1.676e-06          isw=2.158e-11                n=1.000e+00 ns=1.000e+00 \
minr=0.100e+00   imax=(1.000e+00/area) \
cj0=8.798e-05        m=2.737e-01                  vj=5.300e-01 tt=0.000e+00 \
cjsw=6.611e-10       mjsw=2.122e-01             vjsw=5.300e-01 fc=0.000e+00\
af=1.000e+00     kf=0.000e+00            xti=1.366e+00
ends modn30mnwd
// ----------------------------------------------------------------------
// Owner: austriamicrosystems
// HIT-Kit: Digital
// ************************ SIMULATION PARAMETERS ************************
//  ----------------------------------------------------------------------
//  format    : Spectre (Spectre Direct)
//  model     : MOS BSIM3v3
//  process   : c35
//  revision  : ;
//  extracted : B58737.W09PE6; 2008-06; kmo(5966)
//  doc#      : ENG-327 Rev.2.0
//  ----------------------------------------------------------------------
//                        WORST CASE SPEED CONDITION
//  ----------------------------------------------------------------------
//  HV-TRANSISTOR
//  ----------------------------------------------------------------------
inline subckt modn18t ( d g s b )
// Parameters: w l nrd nrs ad as pd ps
parameters w=1.0e-6 l=1.0e-6 nrd=0.0 nrs=0.0 ad=0.0 as=0.0 pd=0.0 ps=0.0 mult=1 gv=(2.8290e-07/l + 8.9230e-01) dcdc=1
+ dvthmat=mv_modn18t*(0.78e-08/sqrt(l*w*mult)) dumat=mu_modn18t*(6.9e-09/sqrt(l*w*mult))
if (modn18t==1){
//
modn18t ( d1 g s1 b ) mosinsub w=w l=l nrd=0 nrs=8.0000e-07/w ad=0 as=as pd=0 ps=ps
rd ( d1 d ) resistor r=(1.1350e+00/(w+(2.4730e-06))) tc1=5.0000e-03
xj1 ( d gj d1 ) modn18tjfet1 w=w
xj2 ( d gj d1 ) modn18tjfet2 w=w
e1 ( d1 gj d1 s ) vcvs gain=gv min=-25 max=25
cgdx ( g d ) capacitor c=(5.2800e-10*w)
v1 ( s1 s ) vsource dc=0 type=dc
i1 ( d b ) bsource i=((5.3850e-10)/(l+(0.0000e+00))+(4.8260e-03))*i("v1:p")*(max((v(d,g)+(2.9600e-02)),1e-15))**(3.8580e+00)*exp((-4.2900e+00)/max((v(d,g)+(2.9600e-02)),1e-10))*(w+0.0000e+00)/w/(1+3.3810e+04*exp(5.3330e-03*i("v1:p")/(w+0.0000e+00)))
xdw ( b d1 ) modn18tnwd area=(1e-06*2.35*(w+1e-06*16)) perimeter=(4e-06*2.35+(w+1e-06*16))
}else
modn18t ( d s ) resistor r=1e30
notvalid paramtest errorif=(modn18t==0) \
message="
***************************************************
*
* nmos18t is not valid in selected process option.
*
***************************************************"
//
model mosinsub bsim3v3 version=3.1 type=n  capmod=2.0000e+00 \
 mobmod=1.0000e+00  nqsmod=0.0000e+00  noimod=3.0000e+00 \
   vbox=1.000e+03      k1=7.1253e-01 \
     k2=-4.171e-03      k3=-2.570e+00     k3b=1.9850e+00 \
    nch=2.6530e+17 vth0=5.4760e-01+dvthmat \
   voff=-8.829e-02    dvt0=1.8190e-01    dvt1=1.0200e-01 \
   dvt2=-5.409e-02    keta=-3.582e-02 \
 pscbe1=3.5770e+12  pscbe2=5.7730e-12 \
 alpha0=0.0000e+00   beta0=3.0000e+01 \
  dvt0w=7.9230e-01   dvt1w=6.0330e+05   dvt2w=-2.792e+00 \
     ua=2.1750e-10      ub=4.8850e-19      uc=1.2070e-10 \
u0=3.3700e+02+(3.3700e+02)*dumat \
   dsub=5.2500e+00    eta0=1.0000e-07    etab=-3.000e-01 \
nfactor=8.6770e-01 \
     em=4.1000e+07    pclm=6.0510e+00 \
  drout=5.0000e-01 \
     a0=7.6440e-01      a1=0.0000e+00      a2=1.0000e+00 \
   pvag=0.0000e+00    vsat=5.5760e+04     ags=2.3440e-01      b0=4.4050e-09      b1=2.6720e-02 \
  delta=2.5490e-05 pdiblcb=1.0000e-12 \
pdiblc1=2.2650e+00 pdiblc2=1.0000e-09 \
     w0=-7.990e-01 \
    dlc=-1.040e-06 \
    dwc=1.6680e-07     dwb=0.0000e+00     dwg=0.0000e+00 \
     ll=0.0000e+00      lw=0.0000e+00     lwl=0.0000e+00 \
    lln=1.0000e+00     lwn=1.0000e+00      wl=0.0000e+00 \
     ww=0.0000e+00     wwl=0.0000e+00     wln=1.0000e+00 \
    wwn=1.0000e+00 \
     at=3.3000e+04     ute=-1.720e+00 \
    kt1=-3.210e-01     kt2=2.2000e-02    kt1l=0.0000e+00 \
    ua1=0.0000e+00     ub1=0.0000e+00     uc1=0.0000e+00 \
    prt=0.0000e+00 \
   cgso=1.4100e-10    cgdo=1.0000e-15    cgbo=1.3200e-10 \
   cgdl=4.4020e-10    cgsl=5.0000e-10  ckappa=6.2280e-01 \
     cf=0.0000e+00     elm=5.0000e+00 \
  xpart=5.0000e-01     clc=1.0000e-15     cle=6.0000e-01 \
\
   rdsw=0.0000e+00 \
   cdsc=5.0330e-20   cdscb=2.9060e-04   cdscd=7.3780e-10 \
   prwb=0.0000e+00    prwg=0.0000e+00     cit=7.3780e-08 \
tox=8.1000e-09 \
  ngate=0.0000e+00 \
    nlx=1.4630e-07 \
     xl=0.0000e+00      xw=0.0000e+00 \
     af=2.0045e+00      kf=8.5977e-25      ef=1.0000e+00 \
   noia=4.8618e+18    noib=2.9560e+04    noic=-2.148e-13 \
     rd=0.0000e+00      rs=0.0000e+00     rsh=7.5000e+01 \
   minr=1.000e-03 \
    rdc=0.0000e+00     rsc=0.0000e+00 lint=-3.414e-07 \
wint=1.6680e-07   ldif=0.000e+00    hdif=8.0000e-07 \
     xj=9.0000e-07      js=3.5530e-07 \
      n=1.0000e+00 \
  dskip=no          tlev=0           tlevc=0         \
    jsw=1.7560e-12 \
     cj=1.0500e-03    cjsw=3.1250e-10 \
     fc=0.0000e+00    fcsw=0.000e+00 \
     mj=3.4000e-01    mjsw=2.3000e-01 \
     pb=6.9000e-01    pbsw=6.9000e-01     xti=2.0260e+00
ends modn18t
// HV-jfet 1
inline subckt modn18tjfet1 (d b s)
parameters w=1e-6
modn18tjfet1 (d b s) rnjfetinsub
model rnjfetinsub jfet type=n \
beta=3.5710e+00/(1+(1.6000e-03)*(temp-(2.7000e+01)))*(w+(2.4730e-06))/(1+(5.0000e-03)*(temp-27)) \
vto=-7.402e+00*(1+(1.6000e-03)*(temp-(2.7000e+01))) \
lambda=0.0000e+00 \
is=0.0000e+00  pb=5.0000e-01 \
cgs=0.0000e+00 rs=0.0000e+00 \
cgd=0.0000e+00 rd=0.0000e+00
ends modn18tjfet1
// HV-jfet 2
inline subckt  modn18tjfet2 (d b s)
parameters w=1e-6
modn18tjfet2 (d b s) rnjfetinsub
model rnjfetinsub jfet type=n \
beta=1.7520e+00/(1+(1.6000e-03)*(temp-(2.7000e+01)))*(w+(2.4730e-06))/(1+(5.0000e-03)*(temp-27)) \
vto=-7.947e+00*(1+(1.6000e-03)*(temp-(2.7000e+01))) \
lambda=0.0000e+00 \
is=0.0000e+00  pb=5.0000e-01 \
cgs=0.0000e+00 rs=0.0000e+00 \
cgd=0.0000e+00 rd=0.0000e+00
ends modn18tjfet2
//

inline subckt modn18tnwd ( a c )
parameters area=1.0e-12 perimeter=1.0e-6
modn18tnwd ( a c ) diodeinsub area=area perim=perimeter region=off
model diodeinsub diode level=1 dskip=no \
is=2.159e-06          isw=3.227e-11                n=1.000e+00 ns=1.000e+00 \
minr=0.100e+00   imax=(1.000e+00/area) \
cj0=8.992e-05        m=2.671e-01                  vj=5.300e-01 tt=0.000e+00 \
cjsw=6.406e-10       mjsw=2.161e-01             vjsw=5.300e-01 fc=0.000e+00\
af=1.000e+00     kf=0.000e+00            xti=4.786e-01
ends modn18tnwd

// ----------------------------------------------------------------------
// Owner: austriamicrosystems
// HIT-Kit: Digital
// ************************ SIMULATION PARAMETERS ************************
//  ----------------------------------------------------------------------
//  format    : Spectre (Spectre Direct)
//  model     : MOS HiSIM_HV
//  process   : c35
//  revision  : REVISION 3.0 Wafer C50118W01 2013/12/12;
//  extracted : MCT;
//  doc#      : Eng-327 REV 5.0
//  ----------------------------------------------------------------------
//                        WORST CASE SPEED CONDITION
//  ----------------------------------------------------------------------
//
// UNSYMMETRIC HV-TRANSISTOR WITH EXTENDED PARASITICS
// PARAMS: NRD NRS AD AS PD PS AW PW (SEE NETLIST FORMAT DOC.)
// NMOS: N-Well Diode
// PMOS: P-Well Diode + PSUB+Diode
//  ----------------------------------------------------------------------
inline subckt modpd30m ( d g s b psub )
// Parameters: w l nrd nrs ad as pd ps
parameters w=1.0e-6 l=1.0e-6 nrd=0.0 nrs=0.0 ad=0.0 as=0.0 pd=0.0 ps=0.0 mult=1 dtemp=0
+ isoVoltage=50
+ dvthmat=(mv_modpd30m)*(1.73e-08/sqrt(l*w*mult)) dumat=(mu_modpd30m)*(6.15e-09/sqrt(l*w*mult))
if (modpd30m==1){
modpd30m ( d g s b ) mosinsub w=w l=l nrd=0 nrs=8.0000e-07/w ad=0 as=as pd=0 ps=ps
xpd ( d b ) modpd30mpd area=w*3.7e-06 perimeter=3.7e-06*2*mult
xnwd ( psub b ) modpd30mnwd area=(w+1e-06*23.6)*(l+1e-06*8.25) perimeter=4*(l+1e-06*8.25)+(w+1e-06*23.6)
}else
modpd30m ( d s ) resistor r=1e30
notvalid paramtest errorif=(modpd30m==0) \
message="
***************************************************
*
* pmosd30m is not valid in selected process option.
*
***************************************************"
//
model mosinsub hisim_hv version=1.230e+00 type=p \
 corsrd=3.0000e+00  coovlp=1.0000e+00 coovlps=1.0000e+00 \
 coisub=0.0000e+00  coiigs=0.0000e+00  cogidl=0.0000e+00 \
 coisti=0.0000e+00  coadov=1.0000e+00   conqs=0.0000e+00 \
   corg=0.0000e+00 corbnet=0.0000e+00 coflick=1.0000e+00 \
cothrml=1.0000e+00   coign=0.0000e+00  coiprv=1 \
  codfm=0.0000e+00 coselfheat=1.0000e+00   cosym=0.0000e+00  \
cosubnode=0.0000e+00  cotemp=0.0000e+00 coldrift=1.0000e+00 \
coqovsm=1.0000e+00  shemax=5.0000e+02  copprv=1.0000e+00
***************************************************************************
*                             Extension to LDMOS                          *
***************************************************************************
+loverld=4.5000e-07   lover=4.9860e-08 ldrift1=1.0000e-06 \
ldrift2=1.0000e-06  novers=1.8290e+17   nover=2.0600e+17
***************************************************************************
*                                   Charges                               *
***************************************************************************
+     xl=0.0000e+00      xw=5.3321e-11     xld=0.0000e+00 \
  xldld=-3.000e-07     xwd=1.6634e-06    xwdc=0.0000e+00   xwdld=0.0000e+00 \
     ll=0.0000e+00     lld=0.0000e+00     lln=0.0000e+00      wl=0.0000e+00 \
    wld=0.0000e+00     wln=0.0000e+00      vfbc=-4.271e-01+dvthmat \
    vbi=1.1000e+00      tox=1.6000e-08    ddltmax=2.4843e+00 \
ddltslp=0.0000e+00 ddltict=1.0000e+01   kappa=3.9000e+00
***************************************************************************
*                          Threshold Voltage Shift                        *
***************************************************************************
+  parl2=1.0000e-08      sc1=1.2113e+01     sc2=5.0000e-02 \
    sc3=0.0000e+00     sc4=0.0000e+00  pthrou=0.0000e+00 \
     nsubp=1.3074e+17      lp=1.3447e-07     bs1=0.0000e+00 \
    bs2=9.0000e-01    scp1=1.5395e+00    scp2=1.0000e-01 \
   scp3=0.0000e+00   scp21=0.0000e+00   scp22=0.0000e+00 \
  npext=1.0000e+17   lpext=1.0000e-50
***************************************************************************
*                   Depletion Effect of the Gate Poly-Si                  *
***************************************************************************
+   pgd1=0.0000e+00    pgd2=1.0000e+00    pgd3=8.0000e-01 \
   pgd4=0.0000e+00
***************************************************************************
*                       Quantum Mechanical Effects                        *
***************************************************************************
+   qme1=0.0000e+00    qme2=1.0000e+00    qme3=0.0000e+00
***************************************************************************
*                            Mobility Model                               *
***************************************************************************
+muecb0=1.0000e+02*(1+dumat)     muecb1=7.5427e+01*(1+dumat) mueph0=3.0000e-01 \
mueph1=7.1797e+03*(1+dumat) muephl=-1.230e-01  mueplp=1.0000e+00 \
 muesr0=2.2790e+00      muesr1=8.6146e+15*(1+dumat) muesrl=-1.087e-01 \
 mueslp=1.0000e+00    ndep=1.0000e+00   ndepl=0.0000e+00 \
 ndeplp=1.0000e+00    ninv=5.0000e-01   ninvd=0.0000e+00 \
     bb=1.0000e+00     vmax=6.4148e+06 \
  vover=3.2667e+00 \
 voverp=2.0000e+00
***************************************************************************
*                        Channel Length Modulation                        *
***************************************************************************
+   clm1=5.0000e-01    clm2=4.0000e+00    clm3=1.0000e+00 \
   clm5=1.0000e+00    clm6=0.0000e+00
***************************************************************************
*                          Narrow Channel Effects                         *
***************************************************************************
+    wfc=0.0000e+00   wvth0=-2.159e-01     nsubc=6.6949e+16 \
 nsubcw=0.0000e+00 nsubcwp=1.0000e+00  nsubp0=0.0000e+00 \
 nsubwp=1.0000e+00  muephw=4.5673e+00  muepwp=1.0000e+00 \
 muesrw=7.8626e-02  mueswp=1.0000e+00  vthsti=0.0000e+00 \
  vdsti=0.0000e+00  scsti1=0.0000e+00  scsti2=0.0000e+00 \
   nsti=1.0000e+17    wsti=0.0000e+00   wstil=0.0000e+00 \
 wstilp=1.0000e+00   wstiw=0.0000e+00  wstiwp=1.0000e+00 \
    wl1=0.0000e+00    wl1p=1.0000e+00     wl2=-1.938e-01 \
   wl2p=1.0000e+00  muephs=-5.777e-01  muepsp=1.0000e+00 \
 vovers=-1.000e-01 voversp=0.0000e+00
***************************************************************************
*                          Source/Drain Diffusion                         *
***************************************************************************
+nsubpsti1=0.0000e+00 nsubpsti2=0.0000e+00 nsubpsti3=1.0000e+00 \
muesti1=0.0000e+00 muesti2=0.0000e+00 muesti3=1.0000e+00 \
  saref=1.0000e-06   sbref=1.0000e-06
***************************************************************************
*                         Temperature Dependencies                        *
***************************************************************************
+    eg0=1.1790e+00  bgtmp1=9.0255e-05  bgtmp2=-2.432e-07 \
 muetmp=1.2226e+00    tnom=2.7000e+01    vtmp=3.6866e-01 \
   egig=0.0000e+00 igtemp2=0.0000e+00 igtemp3=0.0000e+00 \
rdtemp1=3.4836e-04 rdtemp2=2.6548e-06 rdvdtemp1=-5.189e-04 \
rdvdtemp2=9.7855e-07
***************************************************************************
*                                Resistances                              *
***************************************************************************
    +rd=8.4693e-03      rs=0.0000e+00     rsh=0.0000e+00 \
   rshg=0.0000e+00    rbpb=5.0000e+01    rbpd=5.0000e+01 \
   rbps=5.0000e+01 \
 rdvg11=6.4018e+00  rdvg12=1.6108e+01     rdvd=9.0086e-02 \
   rdvb=7.4912e-02     rds=-7.748e-01    rdsp=1.0000e+00 \
  rdvdl=0.0000e+00   rdvds=-4.921e-01  rdvdsp=1.0000e+00 \
 rdov11=0.0000e+00  rdov12=1.0000e+00  rdov13=1.0000e+00 \
 rdslp1=0.0000e+00    rd20=0.0000e+00    rd21=1.0000e+00 \
   rd22=-1.312e-01   rd22d=0.0000e+00     rd23=3.7023e-01 \
  rd23l=5.6859e-01  rd23lp=1.0000e+00   rd23s=-1.675e+00 \
 rd23sp=1.0000e+00    rd24=0.0000e+00    rd25=0.0000e+00 \
  gbmin=1.0000e-12
***************************************************************************
*                                Capacitances                             *
***************************************************************************
+    xqy=0.0000e+00    xqy1=0.0000e+00    xqy2=2.0000e+00 \
vfbover=-1.000e+00   qovsm=2.0000e-01   ovslp=2.0000e-08 \
  ovmag=5.0000e+02    cgso=2.3370e-10    cgdo=4.3240e-10 \
   cgbo=1.1000e-10   tpoly=2.0000e-07
***************************************************************************
*                              Leakage Currents                           *
***************************************************************************
+   sub1=5.0000e-02   sub1l=2.5000e-03  sub1lp=1.0000e+00 \
   sub2=3.0048e+01   sub2l=2.0000e-06    svds=8.0000e-01 \
    slg=3.0000e-08    slgl=0.0000e+00   slglp=1.0000e+00 \
   svbs=5.0000e-01   svbsl=0.0000e+00  svbslp=1.0000e+00 \
   svgs=8.0000e-01   svgsl=0.0000e+00  svgslp=1.0000e+00 \
  svgsw=0.0000e+00  svgswp=1.0000e+00   ibpc1=0.0000e+00 \
  ibpc2=0.0000e+00  subld1=0.0000e+00  subld2=0.0000e+00 \
 gleak1=5.0000e+01  gleak2=1.0000e+07  gleak3=6.0000e-02 \
 gleak4=4.0000e+00  gleak5=7.5000e+03  gleak6=2.5000e-01 \
 gleak7=1.0000e-06   glkb1=5.0000e-16   glkb2=1.0000e+00 \
  glkb3=0.0000e+00  glksd1=1.0000e-15  glksd2=1.0000e-02 \
 glksd3=-1.000e-02 glpart1=5.0000e-01     fn1=0.0000e+00 \
    fn2=0.0000e+00     fn3=0.0000e+00    fvbs=0.0000e+00 \
  gidl1=2.0000e+00   gidl2=3.0000e+07   gidl3=9.0000e-01 \
  gidl4=9.0000e-01   gidl5=2.0000e-01
***************************************************************************
*                             S/B and D/B Diodes                          *
***************************************************************************
+    js0=3.0890e-07   js0sw=1.1310e-13      nj=1.0000e+00 \
   njsw=1.0000e+00     xti=3.8400e+00    xti2=3.8400e+00 \
   divx=0.0000e+00    cisb=0.0000e+00     cvb=0.0000e+00 \
  ctemp=0.0000e+00   cisbk=0.0000e+00    cvbk=0.0000e+00 \
     cj=1.5232e-03    cjsw=3.9200e-10   cjswg=3.5000e-10 \
     mj=5.4000e-01    mjsw=4.6000e-01   mjswg=4.6000e-01 \
     pb=1.0200e+00    pbsw=1.0200e+00   pbswg=1.0200e+00 \
 vdiffj=6.0000e-04
***************************************************************************
*                                   Noise                                 *
***************************************************************************
+  nftrp=3.2435e+07   nfalp=1.5485e-18     cit=0.0000e+00 \
  falph=1.0000e+00
***************************************************************************
*                           Non Quasi Static Model                        *
***************************************************************************
+   dly1=1.0000e-10    dly2=7.0000e-01    dly3=8.0000e-07 \
  dlyov=0.0000e+00
***************************************************************************
*                            Self heating Effect                          *
***************************************************************************
+   rth0=5.5684e-01    cth0=1.0000e-07   rth0w=-8.500e+00 \
 rth0wp=1.0000e+00  rth0nf=0.0000e+00
***************************************************************************
*                                   DFM                                   *
***************************************************************************
+ mphdfm=-3.000e-01
***************************************************************************
*                         Additional Node                                 *
***************************************************************************
+ pzadd0=5.0000e-03  vzadd0=1.0000e-02 \
 rdict1=1.0000e+00  rdict2=0.0000e+00  rdvdlp=1.0000e+00 \
 vbsmin=-1.050e+01  rdslp2=1.0000e+00
***************************************************************************
*                         Additional Node                                 *
***************************************************************************
+ rdvsub=3.0000e-01 rdvdsub=1.0000e+00  ddrift=1.0000e-06 \
 vbisub=7.0000e-01 nsubsub=1.0000e+15
ends modpd30m
//

inline subckt modpd30mpd ( a c )
parameters area=1.0e-12 perimeter=1.0e-6
modpd30mpd ( a c ) diodeinsub area=area perim=perimeter region=off
model diodeinsub diode level=1 dskip=no \
  is=6.1140e-07          isw=2.4910e-13 \
   n=1.0400e+00           ns=1.0400e+00 \
minr=0.100e+00          imax=(1.000e+00/area) \
 cj0=1.2340e-03           m=6.2660e-01 \
  vj=1.0200e+00           tt=0.000e+00 \
cjsw=2.8230e-10         mjsw=4.8760e-01 \
vjsw=1.0200e+00           fc=0.000e+00 \
  af=1.000e+00             kf=0.000e+00 \
 xti=2.7630e+00
ends modpd30mpd
//

inline subckt modpd30mnwd ( a c )
parameters area=1.0e-12 perimeter=1.0e-6
modpd30mnwd ( a c ) diodeinsub area=area perim=perimeter region=off
model diodeinsub diode level=1 dskip=no \
  is=7.101e-06          isw=5.386e-12 \
   n=1.000e+00      ns=1.000e+00 \
minr=0.100e+00    imax=(1.000e+00/area) \
 cj0=3.850e-04           m=2.982e-01 \
  vj=5.300e-01          vjsw=5.300e-01 \
  fc=0.000e+00        tt=0.000e+00 \
cjsw=0.000e+00       mjsw=4.401e-01 \
  af=1.000e+00     kf=0.000e+00 \
 xti=-3.138e+00
ends modpd30mnwd

// ----------------------------------------------------------------------
// Owner: austriamicrosystems
// HIT-Kit: Digital
// ************************ SIMULATION PARAMETERS ************************
//  ----------------------------------------------------------------------
//  format    : Spectre (Spectre Direct)
//  model     : MOS HiSIM_HV
//  process   : c35
//  revision  : REVISION 1.0 Wafer C50118W01 2013/12/12;
//  extracted : MCT;
//  doc#      : Eng-327 REV 5.0
//  ----------------------------------------------------------------------
//                        WORST CASE SPEED CONDITION
//  ----------------------------------------------------------------------
//
// UNSYMMETRIC HV-TRANSISTOR WITH EXTENDED PARASITICS
// PARAMS: NRD NRS AD AS PD PS AW PW (SEE NETLIST FORMAT DOC.)
// NMOS: N-Well Diode
// PMOS: P-Well Diode + PSUB+Diode
//  ----------------------------------------------------------------------
inline subckt modp30m ( d g s b psub )
// Parameters: w l nrd nrs ad as pd ps
parameters w=1.0e-6 l=1.0e-6 nrd=0.0 nrs=0.0 ad=0.0 as=0.0 pd=0.0 ps=0.0 mult=1 dtemp=0
+ isoVoltage=50
+ dvthmat=(mv_modp30m)*(1.73e-08/sqrt(l*w*mult)) dumat=(mu_modp30m)*(6.15e-09/sqrt(l*w*mult))
if (modp30m==1){
modp30m ( d g s b ) mosinsub w=w l=l nrd=0 nrs=8.0000e-07/w ad=0 as=as pd=0 ps=ps
xpd ( d b ) modp30mpd area=w*3.7e-06 perimeter=3.7e-06*2*mult
xnwd ( psub b ) modp30mnwd area=(w+1e-06*23.6)*(l+1e-06*8.25) perimeter=4*(l+1e-06*8.25)+(w+1e-06*23.6)
}else
modp30m ( d s ) resistor r=1e30
notvalid paramtest errorif=(modp30m==0) \
message="
***************************************************
*
* pmosd30m is not valid in selected process option.
*
***************************************************"
//
model mosinsub hisim_hv version=1.230e+00 type=p \
 corsrd=3.0000e+00  coovlp=1.0000e+00 coovlps=1.0000e+00 \
 coisub=0.0000e+00  coiigs=0.0000e+00  cogidl=0.0000e+00 \
 coisti=0.0000e+00  coadov=1.0000e+00   conqs=0.0000e+00 \
   corg=0.0000e+00 corbnet=0.0000e+00 coflick=1.0000e+00 \
cothrml=1.0000e+00   coign=0.0000e+00  coiprv=1 \
  codfm=0.0000e+00 coselfheat=1.0000e+00   cosym=0.0000e+00  \
cosubnode=0.0000e+00  cotemp=0.0000e+00 coldrift=1.0000e+00 \
coqovsm=1.0000e+00  shemax=5.0000e+02  copprv=1.0000e+00
***************************************************************************
*                             Extension to LDMOS                          *
***************************************************************************
+loverld=4.5000e-07   lover=4.9860e-08 ldrift1=1.0000e-06 \
ldrift2=1.0000e-06  novers=1.8290e+17   nover=2.0600e+17
***************************************************************************
*                                   Charges                               *
***************************************************************************
+     xl=0.0000e+00      xw=5.3321e-11     xld=0.0000e+00 \
  xldld=-3.000e-07     xwd=1.6634e-06    xwdc=0.0000e+00   xwdld=0.0000e+00 \
     ll=0.0000e+00     lld=0.0000e+00     lln=0.0000e+00      wl=0.0000e+00 \
    wld=0.0000e+00     wln=0.0000e+00      vfbc=-4.271e-01+dvthmat \
    vbi=1.1000e+00      tox=1.6000e-08    ddltmax=2.4843e+00 \
ddltslp=0.0000e+00 ddltict=1.0000e+01   kappa=3.9000e+00
***************************************************************************
*                          Threshold Voltage Shift                        *
***************************************************************************
+  parl2=1.0000e-08      sc1=1.2113e+01     sc2=5.0000e-02 \
    sc3=0.0000e+00     sc4=0.0000e+00  pthrou=0.0000e+00 \
     nsubp=1.3074e+17      lp=1.3447e-07     bs1=0.0000e+00 \
    bs2=9.0000e-01    scp1=1.5395e+00    scp2=1.0000e-01 \
   scp3=0.0000e+00   scp21=0.0000e+00   scp22=0.0000e+00 \
  npext=1.0000e+17   lpext=1.0000e-50
***************************************************************************
*                   Depletion Effect of the Gate Poly-Si                  *
***************************************************************************
+   pgd1=0.0000e+00    pgd2=1.0000e+00    pgd3=8.0000e-01 \
   pgd4=0.0000e+00
***************************************************************************
*                       Quantum Mechanical Effects                        *
***************************************************************************
+   qme1=0.0000e+00    qme2=1.0000e+00    qme3=0.0000e+00
***************************************************************************
*                            Mobility Model                               *
***************************************************************************
+muecb0=1.0000e+02*(1+dumat)     muecb1=7.5427e+01*(1+dumat) mueph0=3.0000e-01 \
mueph1=7.1797e+03*(1+dumat) muephl=-1.230e-01  mueplp=1.0000e+00 \
 muesr0=2.2790e+00      muesr1=8.6146e+15*(1+dumat) muesrl=-1.087e-01 \
 mueslp=1.0000e+00    ndep=1.0000e+00   ndepl=0.0000e+00 \
 ndeplp=1.0000e+00    ninv=5.0000e-01   ninvd=0.0000e+00 \
     bb=1.0000e+00     vmax=6.4148e+06 \
  vover=3.2667e+00 \
 voverp=2.0000e+00
***************************************************************************
*                        Channel Length Modulation                        *
***************************************************************************
+   clm1=5.0000e-01    clm2=4.0000e+00    clm3=1.0000e+00 \
   clm5=1.0000e+00    clm6=0.0000e+00
***************************************************************************
*                          Narrow Channel Effects                         *
***************************************************************************
+    wfc=0.0000e+00   wvth0=-2.159e-01     nsubc=6.6949e+16 \
 nsubcw=0.0000e+00 nsubcwp=1.0000e+00  nsubp0=0.0000e+00 \
 nsubwp=1.0000e+00  muephw=4.5673e+00  muepwp=1.0000e+00 \
 muesrw=7.8626e-02  mueswp=1.0000e+00  vthsti=0.0000e+00 \
  vdsti=0.0000e+00  scsti1=0.0000e+00  scsti2=0.0000e+00 \
   nsti=1.0000e+17    wsti=0.0000e+00   wstil=0.0000e+00 \
 wstilp=1.0000e+00   wstiw=0.0000e+00  wstiwp=1.0000e+00 \
    wl1=0.0000e+00    wl1p=1.0000e+00     wl2=-1.938e-01 \
   wl2p=1.0000e+00  muephs=-5.777e-01  muepsp=1.0000e+00 \
 vovers=-1.000e-01 voversp=0.0000e+00
***************************************************************************
*                          Source/Drain Diffusion                         *
***************************************************************************
+nsubpsti1=0.0000e+00 nsubpsti2=0.0000e+00 nsubpsti3=1.0000e+00 \
muesti1=0.0000e+00 muesti2=0.0000e+00 muesti3=1.0000e+00 \
  saref=1.0000e-06   sbref=1.0000e-06
***************************************************************************
*                         Temperature Dependencies                        *
***************************************************************************
+    eg0=1.1790e+00  bgtmp1=9.0255e-05  bgtmp2=-2.432e-07 \
 muetmp=1.2226e+00    tnom=2.7000e+01    vtmp=3.6866e-01 \
   egig=0.0000e+00 igtemp2=0.0000e+00 igtemp3=0.0000e+00 \
rdtemp1=3.4836e-04 rdtemp2=2.6548e-06 rdvdtemp1=-5.189e-04 \
rdvdtemp2=9.7855e-07
***************************************************************************
*                                Resistances                              *
***************************************************************************
    +rd=8.4693e-03      rs=0.0000e+00     rsh=0.0000e+00 \
   rshg=0.0000e+00    rbpb=5.0000e+01    rbpd=5.0000e+01 \
   rbps=5.0000e+01 \
 rdvg11=6.4018e+00  rdvg12=1.6108e+01     rdvd=9.0086e-02 \
   rdvb=7.4912e-02     rds=-7.748e-01    rdsp=1.0000e+00 \
  rdvdl=0.0000e+00   rdvds=-4.921e-01  rdvdsp=1.0000e+00 \
 rdov11=0.0000e+00  rdov12=1.0000e+00  rdov13=1.0000e+00 \
 rdslp1=0.0000e+00    rd20=0.0000e+00    rd21=1.0000e+00 \
   rd22=-1.312e-01   rd22d=0.0000e+00     rd23=3.7023e-01 \
  rd23l=5.6859e-01  rd23lp=1.0000e+00   rd23s=-1.675e+00 \
 rd23sp=1.0000e+00    rd24=0.0000e+00    rd25=0.0000e+00 \
  gbmin=1.0000e-12
***************************************************************************
*                                Capacitances                             *
***************************************************************************
+    xqy=0.0000e+00    xqy1=0.0000e+00    xqy2=2.0000e+00 \
vfbover=-1.000e+00   qovsm=2.0000e-01   ovslp=2.0000e-08 \
  ovmag=5.0000e+02    cgso=2.3370e-10    cgdo=4.3240e-10 \
   cgbo=1.1000e-10   tpoly=2.0000e-07
***************************************************************************
*                              Leakage Currents                           *
***************************************************************************
+   sub1=5.0000e-02   sub1l=2.5000e-03  sub1lp=1.0000e+00 \
   sub2=3.0048e+01   sub2l=2.0000e-06    svds=8.0000e-01 \
    slg=3.0000e-08    slgl=0.0000e+00   slglp=1.0000e+00 \
   svbs=5.0000e-01   svbsl=0.0000e+00  svbslp=1.0000e+00 \
   svgs=8.0000e-01   svgsl=0.0000e+00  svgslp=1.0000e+00 \
  svgsw=0.0000e+00  svgswp=1.0000e+00   ibpc1=0.0000e+00 \
  ibpc2=0.0000e+00  subld1=0.0000e+00  subld2=0.0000e+00 \
 gleak1=5.0000e+01  gleak2=1.0000e+07  gleak3=6.0000e-02 \
 gleak4=4.0000e+00  gleak5=7.5000e+03  gleak6=2.5000e-01 \
 gleak7=1.0000e-06   glkb1=5.0000e-16   glkb2=1.0000e+00 \
  glkb3=0.0000e+00  glksd1=1.0000e-15  glksd2=1.0000e-02 \
 glksd3=-1.000e-02 glpart1=5.0000e-01     fn1=0.0000e+00 \
    fn2=0.0000e+00     fn3=0.0000e+00    fvbs=0.0000e+00 \
  gidl1=2.0000e+00   gidl2=3.0000e+07   gidl3=9.0000e-01 \
  gidl4=9.0000e-01   gidl5=2.0000e-01
***************************************************************************
*                             S/B and D/B Diodes                          *
***************************************************************************
+    js0=3.0890e-07   js0sw=1.1310e-13      nj=1.0000e+00 \
   njsw=1.0000e+00     xti=3.8400e+00    xti2=3.8400e+00 \
   divx=0.0000e+00    cisb=0.0000e+00     cvb=0.0000e+00 \
  ctemp=0.0000e+00   cisbk=0.0000e+00    cvbk=0.0000e+00 \
     cj=1.5232e-03    cjsw=3.9200e-10   cjswg=3.5000e-10 \
     mj=5.4000e-01    mjsw=4.6000e-01   mjswg=4.6000e-01 \
     pb=1.0200e+00    pbsw=1.0200e+00   pbswg=1.0200e+00 \
 vdiffj=6.0000e-04
***************************************************************************
*                                   Noise                                 *
***************************************************************************
+  nftrp=3.2435e+07   nfalp=1.5485e-18     cit=0.0000e+00 \
  falph=1.0000e+00
***************************************************************************
*                           Non Quasi Static Model                        *
***************************************************************************
+   dly1=1.0000e-10    dly2=7.0000e-01    dly3=8.0000e-07 \
  dlyov=0.0000e+00
***************************************************************************
*                            Self heating Effect                          *
***************************************************************************
+   rth0=5.5684e-01    cth0=1.0000e-07   rth0w=-8.500e+00 \
 rth0wp=1.0000e+00  rth0nf=0.0000e+00
***************************************************************************
*                                   DFM                                   *
***************************************************************************
+ mphdfm=-3.000e-01
***************************************************************************
*                         Additional Node                                 *
***************************************************************************
+ pzadd0=5.0000e-03  vzadd0=1.0000e-02 \
 rdict1=1.0000e+00  rdict2=0.0000e+00  rdvdlp=1.0000e+00 \
 vbsmin=-1.050e+01  rdslp2=1.0000e+00
***************************************************************************
*                         Additional Node                                 *
***************************************************************************
+ rdvsub=3.0000e-01 rdvdsub=1.0000e+00  ddrift=1.0000e-06 \
 vbisub=7.0000e-01 nsubsub=1.0000e+15
ends modp30m
//

inline subckt modp30mpd ( a c )
parameters area=1.0e-12 perimeter=1.0e-6
modp30mpd ( a c ) diodeinsub area=area perim=perimeter region=off
model diodeinsub diode level=1 dskip=no \
  is=6.1140e-07          isw=2.4910e-13 \
   n=1.0400e+00           ns=1.0400e+00 \
minr=0.100e+00          imax=(1.000e+00/area) \
 cj0=1.2340e-03           m=6.2660e-01 \
  vj=1.0200e+00           tt=0.000e+00 \
cjsw=2.8230e-10         mjsw=4.8760e-01 \
vjsw=1.0200e+00           fc=0.000e+00 \
  af=1.000e+00             kf=0.000e+00 \
 xti=2.7630e+00
ends modp30mpd
//

inline subckt modp30mnwd ( a c )
parameters area=1.0e-12 perimeter=1.0e-6
modp30mnwd ( a c ) diodeinsub area=area perim=perimeter region=off
model diodeinsub diode level=1 dskip=no \
  is=7.101e-06          isw=5.386e-12 \
   n=1.000e+00      ns=1.000e+00 \
minr=0.100e+00    imax=(1.000e+00/area) \
 cj0=3.850e-04           m=2.982e-01 \
  vj=5.300e-01          vjsw=5.300e-01 \
  fc=0.000e+00        tt=0.000e+00 \
cjsw=0.000e+00       mjsw=4.401e-01 \
  af=1.000e+00     kf=0.000e+00 \
 xti=-3.138e+00
ends modp30mnwd

// ----------------------------------------------------------------------
// Owner: austriamicrosystems
// HIT-Kit: Digital
// ************************ SIMULATION PARAMETERS ************************
//  ----------------------------------------------------------------------
//  format    : Spectre (Spectre Direct)
//  model     : MOS BSIM3v3
//  process   : C35
//  revision  : 1.0;
//  extracted : C18069; 28.08.2011; bse (5866)
//  doc#      : Eng-?? REV_0
//  ----------------------------------------------------------------------
//                         WORST CASE SPEED CONDITION
//
//  ----------------------------------------------------------------------
//
inline subckt nmosw_2n ( d g s b )
parameters w=1.0e-6 l=1.0e-6 nrd=0.0 nrs=0.0 ad=0.0 as=0.0 pd=0.0 ps=0.0 ng=1
+ ws= w
+ ls= l
+ shk=1
+ dvthmat=(mv_nmosw_2n)*(0.67e-08/sqrt(ls*ws*ng)) dumat=(mu_nmosw_2n)*(4.9e-9/sqrt(ls*ws*ng))
//
if (modn==1)
nmosw_2n ( d g s b ) mosinsub w=ws l=ls nrd=8.0000e-07/ws nrs=8.0000e-07/ws ad=ad as=as pd=pd ps=ps m=ng
else
nmosw_2n ( d s ) resistor r=1e30
notvalid paramtest errorif=(modn==0) \
message="
***************************************************
*
* nmos is not valid in selected process option.
*
***************************************************"
model mosinsub bsim3v3 version=3.2400e+00  type=n  capmod=3.0000e+00 \
 mobmod=1.0000e+00  nqsmod=0.0000e+00  noimod=3.0000e+00 \
   vbox=1.000e+03      k1=7.1820e-01 \
     k2=0.0000e+00      k3=3.0270e-02     k3b=-1.089e-02 \
    nch=2.4200e+17 vth0=5.4780e-01+dvthmat \
   voff=-7.600e-02    dvt0=2.1160e+01    dvt1=1.0640e+00 \
   dvt2=3.0590e-02    keta=-1.200e-02 \
 pscbe1=1.0000e+30  pscbe2=1.0000e-06 \
 alpha0=1.9040e-06  alpha1=2.5000e+00   beta0=2.0000e+01 \
  dvt0w=2.0000e+00   dvt1w=1.6970e+06   dvt2w=-1.556e-02 \
     ua=-3.981e-10      ub=2.6890e-18      uc=6.9180e-11 \
u0=4.1460e+02+(4.1460e+02)*dumat \
   dsub=5.0000e-01    eta0=1.4790e-02    etab=-5.280e-02 \
nfactor=2.6780e-01 \
     em=4.1000e+07    pclm=9.6570e-01 \
  drout=5.0000e-01 \
     a0=2.0840e+00      a1=0.0000e+00      a2=1.0000e+00 \
   pvag=1.3460e-01    vsat=1.0200e+05     ags=3.6080e-01      b0=5.0200e-08      b1=1.0060e-07 \
  delta=2.3500e-03 pdiblcb=3.2150e-01 \
pdiblc1=1.0800e-01 pdiblc2=1.6220e-03 \
     w0=-3.185e-07 \
    dlc=-1.588e-08 \
dwc=-3.263e-01*l+1.5050e-07    dwb=0.0000e+00     dwg=-9.302e-09 \
     ll=1.0680e-13      lw=0.0000e+00     lwl=0.0000e+00 \
    lln=1.0000e+00     lwn=1.0000e+00      wl=2.8610e-13 \
     ww=-1.130e-14     wwl=-9.411e-21     wln=1.0000e+00 \
     wr=1.0000e+00     wwn=1.0000e+00 \
     at=2.5000e+04     ute=-1.700e+00 \
    kt1=-3.100e-01     kt2=-1.720e-02    kt1l=0.0000e+00 \
    ua1=0.0000e+00     ub1=0.0000e+00     uc1=0.0000e+00 \
    prt=3.0000e+01 \
   cgso=1.0850e-12    cgdo=1.0850e-12    cgbo=1.9040e-08 \
   cgdl=3.1950e-10    cgsl=3.1950e-10  ckappa=2.6020e+00 \
     cf=0.0000e+00     elm=5.0000e+00 \
  xpart=1.0000e+00     clc=1.0000e-15     cle=6.0000e-01 \
\
   rdsw=1.1390e+03 \
   cdsc=0.0000e+00   cdscb=1.5000e-09   cdscd=0.0000e+00 \
   prwb=-5.000e-02    prwg=1.3340e-02     cit=8.0260e-04 \
tox=8.1750e-09 \
  ngate=1.0000e+00 \
    nlx=1.7000e-07 \
     xl=7.2040e-08      xw=0.0000e+00 \
     af=1.3760e+00      kf=3.3960e-26      ef=1.0000e+00 \
   noia=1.3990e+20    noib=2.7070e+05    noic=-4.680e-12 \
     rd=0.0000e+00      rs=0.0000e+00     rsh=8.5000e+01 \
   minr=1.000e-03 \
    rdc=0.0000e+00     rsc=0.0000e+00 lint=-3.098e-07 \
wint=-8.969e-07   ldif=0.000e+00    hdif=8.0000e-07 \
     xj=3.0000e-07      js=5.1000e-07 \
      n=1.0000e+00 \
  dskip=no          tlev=0           tlevc=0         \
    jsw=6.0000e-13 \
     cj=1.0380e-03    cjsw=3.1250e-10 \
     fc=0.0000e+00    fcsw=0.000e+00 \
     mj=3.4000e-01    mjsw=2.3000e-01 \
     pb=6.9000e-01    pbsw=6.9000e-01     xti=2.0300e+00
ends nmosw_2n

// ----------------------------------------------------------------------

// ----------------------------------------------------------------------
// Owner: austriamicrosystems
// HIT-Kit: Digital
// ************************ SIMULATION PARAMETERS ************************
//  ----------------------------------------------------------------------
//  format    : Spectre (Spectre Direct)
//  model     : MOS BSIM3v3
//  process   : C35
//  revision  : 1.0;
//  extracted : C18069; 28.08.2011; bse (5866)
//  doc#      : Eng-?? REV_0
//  ----------------------------------------------------------------------
//                         WORST CASE SPEED CONDITION
//
//  ----------------------------------------------------------------------
//
inline subckt nmosw_3n ( d g s b )
parameters w=1.0e-6 l=1.0e-6 nrd=0.0 nrs=0.0 ad=0.0 as=0.0 pd=0.0 ps=0.0 ng=1
+ ws= w
+ ls= l
+ shk=1
+ dvthmat=(mv_nmosw_3n)*(0.67e-08/sqrt(ls*ws*ng)) dumat=(mu_nmosw_3n)*(4.9e-9/sqrt(ls*ws*ng))
//
if (modn==1)
nmosw_3n ( d g s b ) mosinsub w=ws l=ls nrd=8.0000e-07/ws nrs=8.0000e-07/ws ad=ad as=as pd=pd ps=ps m=ng
else
nmosw_3n ( d s ) resistor r=1e30
notvalid paramtest errorif=(modn==0) \
message="
***************************************************
*
* nmos is not valid in selected process option.
*
***************************************************"
model mosinsub bsim3v3 version=3.2400e+00  type=n  capmod=3.0000e+00 \
 mobmod=1.0000e+00  nqsmod=0.0000e+00  noimod=3.0000e+00 \
   vbox=1.000e+03      k1=7.1820e-01 \
     k2=0.0000e+00      k3=3.0270e-02     k3b=-1.089e-02 \
    nch=2.4200e+17 vth0=5.4780e-01+dvthmat \
   voff=-7.600e-02    dvt0=2.1160e+01    dvt1=1.0640e+00 \
   dvt2=3.0590e-02    keta=-1.200e-02 \
 pscbe1=1.0000e+30  pscbe2=1.0000e-06 \
 alpha0=1.9040e-06  alpha1=2.5000e+00   beta0=2.0000e+01 \
  dvt0w=2.0000e+00   dvt1w=1.6970e+06   dvt2w=-1.556e-02 \
     ua=-3.981e-10      ub=2.6890e-18      uc=6.9180e-11 \
u0=4.1460e+02+(4.1460e+02)*dumat \
   dsub=5.0000e-01    eta0=1.4790e-02    etab=-5.280e-02 \
nfactor=2.6780e-01 \
     em=4.1000e+07    pclm=9.6570e-01 \
  drout=5.0000e-01 \
     a0=2.0840e+00      a1=0.0000e+00      a2=1.0000e+00 \
   pvag=1.3460e-01    vsat=1.0200e+05     ags=3.6080e-01      b0=5.0200e-08      b1=1.0060e-07 \
  delta=2.3500e-03 pdiblcb=3.2150e-01 \
pdiblc1=2.3600e-01 pdiblc2=2.4880e-03 \
     w0=-3.185e-07 \
    dlc=-1.588e-08 \
dwc=-3.263e-01*l+1.5050e-07    dwb=0.0000e+00     dwg=-9.302e-09 \
     ll=1.0680e-13      lw=0.0000e+00     lwl=0.0000e+00 \
    lln=1.0000e+00     lwn=1.0000e+00      wl=2.8610e-13 \
     ww=-1.130e-14     wwl=-9.411e-21     wln=1.0000e+00 \
     wr=1.0000e+00     wwn=1.0000e+00 \
     at=2.5000e+04     ute=-1.700e+00 \
    kt1=-3.100e-01     kt2=-1.720e-02    kt1l=0.0000e+00 \
    ua1=0.0000e+00     ub1=0.0000e+00     uc1=0.0000e+00 \
    prt=3.0000e+01 \
   cgso=1.0850e-12    cgdo=1.0850e-12    cgbo=1.9040e-08 \
   cgdl=3.1950e-10    cgsl=3.1950e-10  ckappa=2.6020e+00 \
     cf=0.0000e+00     elm=5.0000e+00 \
  xpart=1.0000e+00     clc=1.0000e-15     cle=6.0000e-01 \
\
   rdsw=1.1390e+03 \
   cdsc=0.0000e+00   cdscb=1.5000e-09   cdscd=0.0000e+00 \
   prwb=-1.471e-01    prwg=1.3340e-02     cit=8.0260e-04 \
tox=8.1750e-09 \
  ngate=1.0000e+00 \
    nlx=1.7000e-07 \
     xl=6.8040e-08      xw=0.0000e+00 \
     af=1.3760e+00      kf=3.3960e-26      ef=1.0000e+00 \
   noia=1.3990e+20    noib=2.7070e+05    noic=-4.680e-12 \
     rd=0.0000e+00      rs=0.0000e+00     rsh=8.5000e+01 \
   minr=1.000e-03 \
    rdc=0.0000e+00     rsc=0.0000e+00 lint=-3.098e-07 \
wint=-8.216e-07   ldif=0.000e+00    hdif=8.0000e-07 \
     xj=3.0000e-07      js=5.1000e-07 \
      n=1.0000e+00 \
  dskip=no          tlev=0           tlevc=0         \
    jsw=6.0000e-13 \
     cj=1.0380e-03    cjsw=3.1250e-10 \
     fc=0.0000e+00    fcsw=0.000e+00 \
     mj=3.4000e-01    mjsw=2.3000e-01 \
     pb=6.9000e-01    pbsw=6.9000e-01     xti=2.0300e+00
ends nmosw_3n

// ----------------------------------------------------------------------

// ----------------------------------------------------------------------
// Owner: austriamicrosystems
// HIT-Kit: Digital
// ************************ SIMULATION PARAMETERS ************************
//  ----------------------------------------------------------------------
//  format    : Spectre (Spectre Direct)
//  model     : MOS BSIM3v3
//  process   : C35
//  revision  : 1.0;
//  extracted : C18069; 28.08.2011; bse (5866)
//  doc#      : Eng-?? REV_0
//  ----------------------------------------------------------------------
//                         WORST CASE SPEED CONDITION
//
//  ----------------------------------------------------------------------
//
inline subckt nmosw_4n ( d g s b )
parameters w=1.0e-6 l=1.0e-6 nrd=0.0 nrs=0.0 ad=0.0 as=0.0 pd=0.0 ps=0.0 ng=1
+ ws= w
+ ls= l
+ shk=1
+ dvthmat=(mv_nmosw_4n)*(0.67e-08/sqrt(ls*ws*ng)) dumat=(mu_nmosw_4n)*(4.9e-9/sqrt(ls*ws*ng))
//
if (modn==1)
nmosw_4n ( d g s b ) mosinsub w=ws l=ls nrd=8.0000e-07/ws nrs=8.0000e-07/ws ad=ad as=as pd=pd ps=ps m=ng
else
nmosw_4n ( d s ) resistor r=1e30
notvalid paramtest errorif=(modn==0) \
message="
***************************************************
*
* nmos is not valid in selected process option.
*
***************************************************"
model mosinsub bsim3v3 version=3.2400e+00  type=n  capmod=3.0000e+00 \
 mobmod=1.0000e+00  nqsmod=0.0000e+00  noimod=3.0000e+00 \
   vbox=1.000e+03      k1=7.1820e-01 \
     k2=0.0000e+00      k3=3.0270e-02     k3b=-1.089e-02 \
    nch=2.4200e+17 vth0=5.4780e-01+dvthmat \
   voff=-7.600e-02    dvt0=2.1160e+01    dvt1=1.0640e+00 \
   dvt2=3.0590e-02    keta=-1.200e-02 \
 pscbe1=1.0000e+30  pscbe2=1.0000e-06 \
 alpha0=1.9040e-06  alpha1=2.5000e+00   beta0=2.0000e+01 \
  dvt0w=2.0000e+00   dvt1w=1.6970e+06   dvt2w=-1.556e-02 \
     ua=-3.981e-10      ub=2.5120e-18      uc=6.9180e-11 \
u0=4.1460e+02+(4.1460e+02)*dumat \
   dsub=5.0000e-01    eta0=1.4790e-02    etab=-5.280e-02 \
nfactor=2.6780e-01 \
     em=4.1000e+07    pclm=9.6570e-01 \
  drout=5.0000e-01 \
     a0=2.0840e+00      a1=0.0000e+00      a2=1.0000e+00 \
   pvag=1.3460e-01    vsat=1.0200e+05     ags=3.1620e-01      b0=5.0200e-08      b1=1.0060e-07 \
  delta=2.3500e-03 pdiblcb=3.2150e-01 \
pdiblc1=8.3400e-01 pdiblc2=2.4880e-03 \
     w0=-3.185e-07 \
    dlc=-1.588e-08 \
dwc=-3.263e-01*l+1.5050e-07    dwb=0.0000e+00     dwg=-9.302e-09 \
     ll=0.0000e+00      lw=0.0000e+00     lwl=0.0000e+00 \
    lln=1.0000e+00     lwn=1.0000e+00      wl=-1.924e-13 \
     ww=0.0000e+00     wwl=0.0000e+00     wln=1.0000e+00 \
     wr=1.0000e+00     wwn=1.0000e+00 \
     at=2.5000e+04     ute=-1.700e+00 \
    kt1=-3.100e-01     kt2=-1.720e-02    kt1l=0.0000e+00 \
    ua1=0.0000e+00     ub1=0.0000e+00     uc1=0.0000e+00 \
    prt=-2.456e+02 \
   cgso=1.0850e-12    cgdo=1.0850e-12    cgbo=1.9040e-08 \
   cgdl=3.1950e-10    cgsl=3.1950e-10  ckappa=2.6020e+00 \
     cf=0.0000e+00     elm=5.0000e+00 \
  xpart=1.0000e+00     clc=1.0000e-15     cle=6.0000e-01 \
\
   rdsw=1.1410e+03 \
   cdsc=0.0000e+00   cdscb=1.5000e-09   cdscd=0.0000e+00 \
   prwb=-7.244e-02    prwg=1.1740e-01     cit=8.0260e-04 \
tox=8.1750e-09 \
  ngate=1.0000e+00 \
    nlx=1.7000e-07 \
     xl=8.0100e-08      xw=0.0000e+00 \
     af=1.3760e+00      kf=3.3960e-26      ef=1.0000e+00 \
   noia=1.3990e+20    noib=2.7070e+05    noic=-4.680e-12 \
     rd=0.0000e+00      rs=0.0000e+00     rsh=8.5000e+01 \
   minr=1.000e-03 \
    rdc=0.0000e+00     rsc=0.0000e+00 lint=-1.868e-07 \
wint=-3.544e-07   ldif=0.000e+00    hdif=8.0000e-07 \
     xj=3.0000e-07      js=5.1000e-07 \
      n=1.0000e+00 \
  dskip=no          tlev=0           tlevc=0         \
    jsw=6.0000e-13 \
     cj=1.0380e-03    cjsw=3.1250e-10 \
     fc=0.0000e+00    fcsw=0.000e+00 \
     mj=3.4000e-01    mjsw=2.3000e-01 \
     pb=6.9000e-01    pbsw=6.9000e-01     xti=2.0300e+00
ends nmosw_4n

// ----------------------------------------------------------------------

// ----------------------------------------------------------------------
// Owner: austriamicrosystems
// HIT-Kit: Digital
// ************************ SIMULATION PARAMETERS ************************
//  ----------------------------------------------------------------------
//  format    : Spectre (Spectre Direct)
//  model     : MOS BSIM3v3
//  process   : C35
//  revision  : 1.0;
//  extracted : C18069; 28.08.2011; bse (5866)
//  doc#      : Eng-?? REV_0
//  ----------------------------------------------------------------------
//                         WORST CASE SPEED CONDITION
//
//  ----------------------------------------------------------------------
//
inline subckt nmosmw_2n ( d g s b )
parameters w=1.0e-6 l=1.0e-6 nrd=0.0 nrs=0.0 ad=0.0 as=0.0 pd=0.0 ps=0.0 ng=1
+ ws= w
+ ls= l
+ shk=1
+ dvthmat=(mv_nmosmw_2n)*(1.03e-08/sqrt(ls*ws*ng)) dumat=(mu_nmosmw_2n)*(3.5e-9/sqrt(ls*ws*ng))
//
if (modnm==1)
nmosmw_2n ( d g s b ) mosinsub w=ws l=ls nrd=6.0000e-07/ws nrs=6.0000e-07/ws ad=ad as=as pd=pd ps=ps m=ng
else
nmosmw_2n ( d s ) resistor r=1e30
notvalid paramtest errorif=(modnm==0) \
message="
***************************************************
*
* nmosm is not valid in selected process option.
*
***************************************************"
model mosinsub bsim3v3 version=3.2400e+00  type=n  capmod=3.0000e+00 \
 mobmod=1.0000e+00  nqsmod=0.0000e+00  noimod=3.0000e+00 \
   vbox=1.000e+03      k1=1.1520e+00 \
     k2=0.0000e+00      k3=-2.500e+00     k3b=-5.640e-02 \
    nch=1.5560e+17 vth0=8.2170e-01+dvthmat \
   voff=-9.684e-02    dvt0=2.0510e+01    dvt1=1.0610e+00 \
   dvt2=2.5970e-02    keta=3.2000e-02 \
 pscbe1=1.0000e+30  pscbe2=1.0000e-06 \
 alpha0=5.5350e-08  alpha1=1.3930e-01   beta0=1.9570e+01 \
  dvt0w=1.0800e+01   dvt1w=3.0990e+06   dvt2w=1.4520e-01 \
     ua=1.4200e-12      ub=1.7380e-18      uc=5.7540e-11 \
u0=4.3850e+02+(4.3850e+02)*dumat \
   dsub=5.0000e-01    eta0=4.0860e-02    etab=-1.000e-03 \
nfactor=8.6050e-01 \
     em=4.1000e+07    pclm=9.0000e-01 \
  drout=5.0000e-01 \
     a0=1.0000e+00      a1=0.0000e+00      a2=1.0000e+00 \
   pvag=6.0000e-02    vsat=5.3380e+04     ags=1.9140e-01      b0=2.0000e-08      b1=1.0000e-08 \
  delta=1.0000e-02 pdiblcb=9.7980e-01 \
pdiblc1=2.4800e-01 pdiblc2=1.2400e-03 \
     w0=3.3160e-08 \
    dlc=1.3960e-09 \
dwc=-2.884e-01*l+1.4740e-07    dwb=8.6800e-09     dwg=-3.770e-09 \
     ll=7.4510e-14      lw=0.0000e+00     lwl=0.0000e+00 \
    lln=1.0000e+00     lwn=1.0000e+00      wl=-3.626e-13 \
     ww=-1.514e-14     wwl=-1.321e-20     wln=1.0000e+00 \
     wr=1.0000e+00     wwn=1.0000e+00 \
     at=3.3000e+04     ute=-1.720e+00 \
    kt1=-4.180e-01     kt2=-4.560e-02    kt1l=0.0000e+00 \
    ua1=0.0000e+00     ub1=0.0000e+00     uc1=0.0000e+00 \
    prt=0.0000e+00 \
   cgso=1.0050e-10    cgdo=1.0050e-10    cgbo=1.7920e-08 \
   cgdl=1.1200e-10    cgsl=1.1200e-10  ckappa=2.9570e+00 \
     cf=0.0000e+00     elm=5.0000e+00 \
  xpart=1.0000e+00     clc=1.0000e-15     cle=6.0000e-01 \
\
   rdsw=3.0420e+03 \
   cdsc=0.0000e+00   cdscb=2.0000e-03   cdscd=0.0000e+00 \
   prwb=5.0000e-02    prwg=4.3480e-03     cit=0.0000e+00 \
tox=1.6000e-08 \
  ngate=1.0000e+00 \
    nlx=1.5690e-07 \
     xl=1.0010e-07      xw=0.0000e+00 \
     af=1.3580e+00      kf=3.4460e-26      ef=1.0000e+00 \
   noia=1.7020e+20    noib=5.4630e+05    noic=-1.400e-11 \
     rd=0.0000e+00      rs=0.0000e+00     rsh=8.9530e+01 \
   minr=1.000e-03 \
    rdc=0.0000e+00     rsc=0.0000e+00 lint=-3.093e-07 \
wint=-8.560e-07   ldif=0.000e+00    hdif=6.0000e-07 \
     xj=3.0000e-07      js=5.1000e-07 \
      n=1.0000e+00 \
  dskip=no          tlev=0           tlevc=0         \
    jsw=6.0000e-13 \
     cj=1.0380e-03    cjsw=3.1250e-10 \
     fc=0.0000e+00    fcsw=0.000e+00 \
     mj=3.4000e-01    mjsw=2.3000e-01 \
     pb=6.9000e-01    pbsw=6.9000e-01     xti=2.0300e+00
ends nmosmw_2n

// ----------------------------------------------------------------------

// ----------------------------------------------------------------------
// Owner: austriamicrosystems
// HIT-Kit: Digital
// ************************ SIMULATION PARAMETERS ************************
//  ----------------------------------------------------------------------
//  format    : Spectre (Spectre Direct)
//  model     : MOS BSIM3v3
//  process   : C35
//  revision  : 1.0;
//  extracted : C18069; 28.08.2011; bse (5866)
//  doc#      : Eng-?? REV_0
//  ----------------------------------------------------------------------
//                         WORST CASE SPEED CONDITION
//
//  ----------------------------------------------------------------------
//
inline subckt nmosmw_3n ( d g s b )
parameters w=1.0e-6 l=1.0e-6 nrd=0.0 nrs=0.0 ad=0.0 as=0.0 pd=0.0 ps=0.0 ng=1
+ ws= w
+ ls= l
+ shk=1
+ dvthmat=(mv_nmosmw_3n)*(1.03e-08/sqrt(ls*ws*ng)) dumat=(mu_nmosmw_3n)*(3.5e-9/sqrt(ls*ws*ng))
//
if (modnm==1)
nmosmw_3n ( d g s b ) mosinsub w=ws l=ls nrd=6.0000e-07/ws nrs=6.0000e-07/ws ad=ad as=as pd=pd ps=ps m=ng
else
nmosmw_3n ( d s ) resistor r=1e30
notvalid paramtest errorif=(modnm==0) \
message="
***************************************************
*
* nmosm is not valid in selected process option.
*
***************************************************"
model mosinsub bsim3v3 version=3.2400e+00  type=n  capmod=3.0000e+00 \
 mobmod=1.0000e+00  nqsmod=0.0000e+00  noimod=3.0000e+00 \
   vbox=1.000e+03      k1=1.1520e+00 \
     k2=0.0000e+00      k3=-2.500e+00     k3b=-5.640e-02 \
    nch=1.5560e+17 vth0=8.2170e-01+dvthmat \
   voff=-9.684e-02    dvt0=2.0510e+01    dvt1=1.0610e+00 \
   dvt2=2.5970e-02    keta=3.2000e-02 \
 pscbe1=1.0000e+30  pscbe2=1.0000e-06 \
 alpha0=5.5350e-08  alpha1=1.3930e-01   beta0=1.9570e+01 \
  dvt0w=1.0800e+01   dvt1w=3.0990e+06   dvt2w=1.4520e-01 \
     ua=1.4200e-12      ub=1.7380e-18      uc=5.7540e-11 \
u0=4.3850e+02+(4.3850e+02)*dumat \
   dsub=5.0000e-01    eta0=4.0860e-02    etab=-1.000e-03 \
nfactor=8.6050e-01 \
     em=4.1000e+07    pclm=9.0000e-01 \
  drout=5.0000e-01 \
     a0=1.0000e+00      a1=0.0000e+00      a2=1.0000e+00 \
   pvag=6.0000e-02    vsat=6.1710e+04     ags=1.9140e-01      b0=2.0000e-08      b1=1.0000e-08 \
  delta=1.0000e-02 pdiblcb=9.7980e-01 \
pdiblc1=1.4000e-01 pdiblc2=1.3490e-03 \
     w0=3.3160e-08 \
    dlc=1.3960e-09 \
dwc=-2.884e-01*l+1.4740e-07    dwb=8.6800e-09     dwg=-3.770e-09 \
     ll=7.4510e-14      lw=0.0000e+00     lwl=0.0000e+00 \
    lln=1.0000e+00     lwn=1.0000e+00      wl=-1.968e-13 \
     ww=-1.514e-14     wwl=-1.321e-20     wln=1.0000e+00 \
     wr=1.0000e+00     wwn=1.0000e+00 \
     at=3.3000e+04     ute=-1.720e+00 \
    kt1=-4.180e-01     kt2=-4.560e-02    kt1l=0.0000e+00 \
    ua1=0.0000e+00     ub1=0.0000e+00     uc1=0.0000e+00 \
    prt=0.0000e+00 \
   cgso=1.0050e-10    cgdo=1.0050e-10    cgbo=1.7920e-08 \
   cgdl=1.1260e-10    cgsl=1.1260e-10  ckappa=2.9570e+00 \
     cf=0.0000e+00     elm=5.0000e+00 \
  xpart=1.0000e+00     clc=1.0000e-15     cle=6.0000e-01 \
\
   rdsw=2.5390e+03 \
   cdsc=0.0000e+00   cdscb=2.0000e-03   cdscd=0.0000e+00 \
   prwb=5.0000e-02    prwg=4.3480e-03     cit=0.0000e+00 \
tox=1.6000e-08 \
  ngate=1.0000e+00 \
    nlx=1.5690e-07 \
     xl=7.6070e-08      xw=0.0000e+00 \
     af=1.3580e+00      kf=3.4460e-26      ef=1.0000e+00 \
   noia=1.7020e+20    noib=5.4630e+05    noic=-1.400e-11 \
     rd=0.0000e+00      rs=0.0000e+00     rsh=8.9530e+01 \
   minr=1.000e-03 \
    rdc=0.0000e+00     rsc=0.0000e+00 lint=-2.609e-07 \
wint=-6.127e-07   ldif=0.000e+00    hdif=6.0000e-07 \
     xj=3.0000e-07      js=5.1000e-07 \
      n=1.0000e+00 \
  dskip=no          tlev=0           tlevc=0         \
    jsw=6.0000e-13 \
     cj=1.0380e-03    cjsw=3.1250e-10 \
     fc=0.0000e+00    fcsw=0.000e+00 \
     mj=3.4000e-01    mjsw=2.3000e-01 \
     pb=6.9000e-01    pbsw=6.9000e-01     xti=2.0300e+00
ends nmosmw_3n

// ----------------------------------------------------------------------

// ----------------------------------------------------------------------
// Owner: austriamicrosystems
// HIT-Kit: Digital
// ************************ SIMULATION PARAMETERS ************************
//  ----------------------------------------------------------------------
//  format    : Spectre (Spectre Direct)
//  model     : MOS BSIM3v3
//  process   : C35
//  revision  : 1.0;
//  extracted : C18069; 28.08.2011; bse (5866)
//  doc#      : Eng-?? REV_0
//  ----------------------------------------------------------------------
//                         WORST CASE SPEED CONDITION
//
//  ----------------------------------------------------------------------
//
inline subckt nmosmw_4n ( d g s b )
parameters w=1.0e-6 l=1.0e-6 nrd=0.0 nrs=0.0 ad=0.0 as=0.0 pd=0.0 ps=0.0 ng=1
+ ws= w
+ ls= l
+ shk=1
+ dvthmat=(mv_nmosmw_4n)*(1.03e-08/sqrt(ls*ws*ng)) dumat=(mu_nmosmw_4n)*(3.5e-9/sqrt(ls*ws*ng))
//
if (modnm==1)
nmosmw_4n ( d g s b ) mosinsub w=ws l=ls nrd=6.0000e-07/ws nrs=6.0000e-07/ws ad=ad as=as pd=pd ps=ps m=ng
else
nmosmw_4n ( d s ) resistor r=1e30
notvalid paramtest errorif=(modnm==0) \
message="
***************************************************
*
* nmosm is not valid in selected process option.
*
***************************************************"
model mosinsub bsim3v3 version=3.2400e+00  type=n  capmod=3.0000e+00 \
 mobmod=1.0000e+00  nqsmod=0.0000e+00  noimod=3.0000e+00 \
   vbox=1.000e+03      k1=1.1520e+00 \
     k2=0.0000e+00      k3=-2.500e+00     k3b=-5.640e-02 \
    nch=1.5560e+17 vth0=8.2170e-01+dvthmat \
   voff=-9.684e-02    dvt0=2.0510e+01    dvt1=1.0610e+00 \
   dvt2=2.5970e-02    keta=3.2000e-02 \
 pscbe1=1.0000e+30  pscbe2=1.0000e-06 \
 alpha0=5.5350e-08  alpha1=1.3930e-01   beta0=1.9570e+01 \
  dvt0w=1.0800e+01   dvt1w=3.0990e+06   dvt2w=1.4520e-01 \
     ua=4.5710e-10      ub=1.7380e-18      uc=5.7540e-11 \
u0=4.3850e+02+(4.3850e+02)*dumat \
   dsub=5.0000e-01    eta0=4.0860e-02    etab=-1.000e-03 \
nfactor=8.6050e-01 \
     em=4.1000e+07    pclm=9.0000e-01 \
  drout=5.0000e-01 \
     a0=1.0000e+00      a1=0.0000e+00      a2=1.0000e+00 \
   pvag=6.0000e-02    vsat=6.3000e+04     ags=1.4990e-01      b0=2.0000e-08      b1=1.0000e-08 \
  delta=1.0000e-02 pdiblcb=9.7980e-01 \
pdiblc1=3.2000e-02 pdiblc2=1.6680e-03 \
     w0=3.3160e-08 \
    dlc=1.3960e-09 \
dwc=-2.884e-01*l+1.4740e-07    dwb=8.6800e-09     dwg=-3.770e-09 \
     ll=6.7850e-14      lw=0.0000e+00     lwl=0.0000e+00 \
    lln=1.0000e+00     lwn=1.0000e+00      wl=-1.989e-13 \
     ww=-1.514e-14     wwl=-1.321e-20     wln=1.0000e+00 \
     wr=1.0000e+00     wwn=1.0000e+00 \
     at=3.3000e+04     ute=-1.720e+00 \
    kt1=-4.180e-01     kt2=-4.560e-02    kt1l=0.0000e+00 \
    ua1=0.0000e+00     ub1=0.0000e+00     uc1=0.0000e+00 \
    prt=0.0000e+00 \
   cgso=1.0050e-10    cgdo=1.0050e-10    cgbo=1.7920e-08 \
   cgdl=1.1200e-10    cgsl=1.1200e-10  ckappa=2.9570e+00 \
     cf=0.0000e+00     elm=5.0000e+00 \
  xpart=1.0000e+00     clc=1.0000e-15     cle=6.0000e-01 \
\
   rdsw=2.7670e+03 \
   cdsc=0.0000e+00   cdscb=2.0000e-03   cdscd=0.0000e+00 \
   prwb=2.0000e-02    prwg=1.0000e-02     cit=0.0000e+00 \
tox=1.6000e-08 \
  ngate=1.0000e+00 \
    nlx=1.5690e-07 \
     xl=6.5900e-08      xw=0.0000e+00 \
     af=1.3580e+00      kf=3.4460e-26      ef=1.0000e+00 \
   noia=1.7020e+20    noib=5.4630e+05    noic=-1.400e-11 \
     rd=0.0000e+00      rs=0.0000e+00     rsh=8.9530e+01 \
   minr=1.000e-03 \
    rdc=0.0000e+00     rsc=0.0000e+00 lint=-2.104e-07 \
wint=-7.006e-07   ldif=0.000e+00    hdif=6.0000e-07 \
     xj=3.0000e-07      js=5.1000e-07 \
      n=1.0000e+00 \
  dskip=no          tlev=0           tlevc=0         \
    jsw=6.0000e-13 \
     cj=1.0380e-03    cjsw=3.1250e-10 \
     fc=0.0000e+00    fcsw=0.000e+00 \
     mj=3.4000e-01    mjsw=2.3000e-01 \
     pb=6.9000e-01    pbsw=6.9000e-01     xti=2.0300e+00
ends nmosmw_4n

// ----------------------------------------------------------------------

// ----------------------------------------------------------------------
// Owner: austriamicrosystems
// HIT-Kit: Digital
// ************************ SIMULATION PARAMETERS ************************
//  ----------------------------------------------------------------------
//  format    : Spectre (Spectre Direct)
//  model     : MOS BSIM3v3
//  process   : C35
//  revision  : 1.0;
//  extracted : C18069; 28.08.2011; bse (5866)
//  doc#      : Eng-?? REV_0
//  ----------------------------------------------------------------------
//                         WORST CASE SPEED CONDITION
//
//  ----------------------------------------------------------------------
//
inline subckt pmosw_2n ( d g s b )
parameters w=1.0e-6 l=1.0e-6 nrd=0.0 nrs=0.0 ad=0.0 as=0.0 pd=0.0 ps=0.0 ng=1
+ ws= w
+ ls= l
+ shk=1
+ dvthmat=(mv_pmosw_2n)*(1.03e-08/sqrt(ls*ws*ng)) dumat=(mu_pmosw_2n)*(4.89e-9/sqrt(ls*ws*ng))
//
if (modp==1)
pmosw_2n ( d g s b ) mosinsub w=ws l=ls nrd=8.0000e-07/ws nrs=8.0000e-07/ws ad=ad as=as pd=pd ps=ps m=ng
else
pmosw_2n ( d s ) resistor r=1e30
notvalid paramtest errorif=(modp==0) \
message="
***************************************************
*
* pmos is not valid in selected process option.
*
***************************************************"
model mosinsub bsim3v3 version=3.2400e+00  type=p  capmod=3.0000e+00 \
 mobmod=1.0000e+00  nqsmod=0.0000e+00  noimod=3.0000e+00 \
   vbox=1.000e+03      k1=4.1980e-01 \
     k2=0.0000e+00      k3=5.2000e+00     k3b=-1.000e+00 \
    nch=1.0480e+17 vth0=-8.534e-01+dvthmat \
   voff=-1.640e-01    dvt0=2.2000e+00    dvt1=6.3470e-01 \
   dvt2=5.3690e-02    keta=-7.600e-03 \
 pscbe1=1.0000e+30  pscbe2=1.0000e-06 \
 alpha0=1.0000e-09  alpha1=1.1750e-02   beta0=2.2870e+01 \
  dvt0w=1.0090e-01   dvt1w=7.3400e+04   dvt2w=-6.310e-03 \
     ua=4.1690e-10      ub=1.9050e-18      uc=-3.631e-11 \
u0=1.5460e+02+(1.5460e+02)*dumat \
   dsub=5.0000e-01    eta0=2.4000e-01    etab=-3.917e-03 \
nfactor=1.0000e+00 \
     em=4.1000e+07    pclm=3.3380e+00 \
  drout=5.0000e-01 \
     a0=9.0000e-01      a1=1.4440e-15      a2=5.0780e-01 \
   pvag=1.0000e-03    vsat=6.0900e+04     ags=2.1480e-01      b0=2.1920e-07      b1=0.0000e+00 \
  delta=1.0000e-02 pdiblcb=1.0000e-02 \
pdiblc1=8.9340e+02 pdiblc2=1.8000e-03 \
     w0=-1.500e-07 \
    dlc=-2.929e-08 \
dwc=-3.000e-01*l+1.5000e-07    dwb=-5.244e-09     dwg=-1.100e-08 \
     ll=3.5530e-15      lw=0.0000e+00     lwl=0.0000e+00 \
    lln=1.0000e+00     lwn=1.0000e+00      wl=-1.712e-12 \
     ww=-4.300e-14     wwl=-2.884e-21     wln=1.0000e+00 \
     wr=1.0000e+00     wwn=1.0000e+00 \
     at=3.3000e+04     ute=-1.300e+00 \
    kt1=-4.740e-01     kt2=-5.440e-02    kt1l=-1.600e-08 \
    ua1=0.0000e+00     ub1=-3.802e-19     uc1=0.0000e+00 \
    prt=0.0000e+00 \
   cgso=9.0000e-11    cgdo=9.0000e-11    cgbo=1.9040e-08 \
   cgdl=1.5180e-10    cgsl=1.5180e-10  ckappa=1.0000e-01 \
     cf=0.0000e+00     elm=5.0000e+00 \
  xpart=1.0000e+00     clc=1.0000e-15     cle=6.0000e-01 \
\
   rdsw=1.0660e+04 \
   cdsc=1.2000e-02   cdscb=9.0000e-03   cdscd=1.0000e-03 \
   prwb=1.9620e-02    prwg=-3.558e-02     cit=0.0000e+00 \
tox=8.2640e-09 \
  ngate=0.0000e+00 \
    nlx=3.0770e-08 \
     xl=2.4000e-07      xw=0.0000e+00 \
     af=1.4050e+00      kf=1.8270e-26      ef=1.0000e+00 \
   noia=7.0910e+18    noib=6.0740e+04    noic=3.7790e-13 \
     rd=0.0000e+00      rs=0.0000e+00     rsh=1.5200e+02 \
   minr=1.000e-03 \
    rdc=0.0000e+00     rsc=0.0000e+00 lint=-7.965e-07 \
wint=-1.959e-06   ldif=0.000e+00    hdif=8.0000e-07 \
     xj=3.0000e-07      js=2.8000e-07 \
      n=1.0000e+00 \
  dskip=no          tlev=0           tlevc=0         \
    jsw=3.7000e-13 \
     cj=1.7000e-03    cjsw=4.3750e-10 \
     fc=0.0000e+00    fcsw=0.000e+00 \
     mj=5.4000e-01    mjsw=4.6000e-01 \
     pb=1.0200e+00    pbsw=1.0200e+00     xti=1.9730e+00
ends pmosw_2n

// ----------------------------------------------------------------------

// ----------------------------------------------------------------------
// Owner: austriamicrosystems
// HIT-Kit: Digital
// ************************ SIMULATION PARAMETERS ************************
//  ----------------------------------------------------------------------
//  format    : Spectre (Spectre Direct)
//  model     : MOS BSIM3v3
//  process   : C35
//  revision  : 1.0;
//  extracted : C18069; 28.08.2011; bse (5866)
//  doc#      : Eng-?? REV_0
//  ----------------------------------------------------------------------
//                         WORST CASE SPEED CONDITION
//
//  ----------------------------------------------------------------------
//
inline subckt pmosw_3n ( d g s b )
parameters w=1.0e-6 l=1.0e-6 nrd=0.0 nrs=0.0 ad=0.0 as=0.0 pd=0.0 ps=0.0 ng=1
+ ws= w
+ ls= l
+ shk=1
+ dvthmat=(mv_pmosw_3n)*(1.03e-08/sqrt(ls*ws*ng)) dumat=(mu_pmosw_3n)*(4.89e-9/sqrt(ls*ws*ng))
//
if (modp==1)
pmosw_3n ( d g s b ) mosinsub w=ws l=ls nrd=8.0000e-07/ws nrs=8.0000e-07/ws ad=ad as=as pd=pd ps=ps m=ng
else
pmosw_3n ( d s ) resistor r=1e30
notvalid paramtest errorif=(modp==0) \
message="
***************************************************
*
* pmos is not valid in selected process option.
*
***************************************************"
model mosinsub bsim3v3 version=3.2400e+00  type=p  capmod=3.0000e+00 \
 mobmod=1.0000e+00  nqsmod=0.0000e+00  noimod=3.0000e+00 \
   vbox=1.000e+03      k1=4.1980e-01 \
     k2=0.0000e+00      k3=5.2000e+00     k3b=-1.000e+00 \
    nch=1.0480e+17 vth0=-8.534e-01+dvthmat \
   voff=-1.640e-01    dvt0=2.2000e+00    dvt1=6.3470e-01 \
   dvt2=5.3690e-02    keta=-7.600e-03 \
 pscbe1=1.0000e+30  pscbe2=1.0000e-06 \
 alpha0=1.0000e-09  alpha1=1.1750e-02   beta0=2.2870e+01 \
  dvt0w=1.0090e-01   dvt1w=7.3400e+04   dvt2w=-6.310e-03 \
     ua=4.1690e-10      ub=1.9050e-18      uc=-3.631e-11 \
u0=1.5460e+02+(1.5460e+02)*dumat \
   dsub=5.0000e-01    eta0=2.4000e-01    etab=-3.917e-03 \
nfactor=1.0000e+00 \
     em=4.1000e+07    pclm=3.5650e+00 \
  drout=5.0000e-01 \
     a0=9.0000e-01      a1=1.4440e-15      a2=5.0780e-01 \
   pvag=4.6400e+00    vsat=1.0000e+05     ags=3.8020e-01      b0=2.1920e-07      b1=0.0000e+00 \
  delta=1.0000e-02 pdiblcb=1.0000e+00 \
pdiblc1=8.3320e+00 pdiblc2=2.0670e-03 \
     w0=-1.500e-07 \
    dlc=-2.929e-08 \
dwc=-3.000e-01*l+1.5000e-07    dwb=-5.244e-09     dwg=-1.100e-08 \
     ll=3.5530e-15      lw=0.0000e+00     lwl=0.0000e+00 \
    lln=1.0000e+00     lwn=1.0000e+00      wl=-5.064e-13 \
     ww=-4.300e-14     wwl=-2.884e-21     wln=1.0000e+00 \
     wr=1.0000e+00     wwn=1.0000e+00 \
     at=3.3000e+04     ute=-1.300e+00 \
    kt1=-4.740e-01     kt2=-5.440e-02    kt1l=-1.600e-08 \
    ua1=0.0000e+00     ub1=-3.802e-19     uc1=0.0000e+00 \
    prt=0.0000e+00 \
   cgso=9.0000e-11    cgdo=9.0000e-11    cgbo=1.9040e-08 \
   cgdl=1.5180e-10    cgsl=1.5180e-10  ckappa=1.0000e-01 \
     cf=0.0000e+00     elm=5.0000e+00 \
  xpart=1.0000e+00     clc=1.0000e-15     cle=6.0000e-01 \
\
   rdsw=5.7750e+03 \
   cdsc=1.2000e-02   cdscb=9.0000e-03   cdscd=1.0000e-03 \
   prwb=1.9620e-02    prwg=-1.019e-02     cit=0.0000e+00 \
tox=8.2640e-09 \
  ngate=0.0000e+00 \
    nlx=3.0770e-08 \
     xl=1.4590e-07      xw=0.0000e+00 \
     af=1.4050e+00      kf=1.8270e-26      ef=1.0000e+00 \
   noia=7.0910e+18    noib=6.0740e+04    noic=3.7790e-13 \
     rd=0.0000e+00      rs=0.0000e+00     rsh=1.5200e+02 \
   minr=1.000e-03 \
    rdc=0.0000e+00     rsc=0.0000e+00 lint=-3.275e-07 \
wint=-9.593e-07   ldif=0.000e+00    hdif=8.0000e-07 \
     xj=3.0000e-07      js=2.8000e-07 \
      n=1.0000e+00 \
  dskip=no          tlev=0           tlevc=0         \
    jsw=3.7000e-13 \
     cj=1.7000e-03    cjsw=4.3750e-10 \
     fc=0.0000e+00    fcsw=0.000e+00 \
     mj=5.4000e-01    mjsw=4.6000e-01 \
     pb=1.0200e+00    pbsw=1.0200e+00     xti=1.9730e+00
ends pmosw_3n

// ----------------------------------------------------------------------

// ----------------------------------------------------------------------
// Owner: austriamicrosystems
// HIT-Kit: Digital
// ************************ SIMULATION PARAMETERS ************************
//  ----------------------------------------------------------------------
//  format    : Spectre (Spectre Direct)
//  model     : MOS BSIM3v3
//  process   : C35
//  revision  : 1.0;
//  extracted : C18069; 28.08.2011; bse (5866)
//  doc#      : Eng-?? REV_0
//  ----------------------------------------------------------------------
//                         WORST CASE SPEED CONDITION
//
//  ----------------------------------------------------------------------
//
inline subckt pmosw_4n ( d g s b )
parameters w=1.0e-6 l=1.0e-6 nrd=0.0 nrs=0.0 ad=0.0 as=0.0 pd=0.0 ps=0.0 ng=1
+ ws= w
+ ls= l
+ shk=1
+ dvthmat=(mv_pmosw_4n)*(1.03e-08/sqrt(ls*ws*ng)) dumat=(mu_pmosw_4n)*(4.89e-9/sqrt(ls*ws*ng))
//
if (modp==1)
pmosw_4n ( d g s b ) mosinsub w=ws l=ls nrd=8.0000e-07/ws nrs=8.0000e-07/ws ad=ad as=as pd=pd ps=ps m=ng
else
pmosw_4n ( d s ) resistor r=1e30
notvalid paramtest errorif=(modp==0) \
message="
***************************************************
*
* pmos is not valid in selected process option.
*
***************************************************"
model mosinsub bsim3v3 version=3.2400e+00  type=p  capmod=3.0000e+00 \
 mobmod=1.0000e+00  nqsmod=0.0000e+00  noimod=3.0000e+00 \
   vbox=1.000e+03      k1=4.1980e-01 \
     k2=0.0000e+00      k3=5.2000e+00     k3b=-1.000e+00 \
    nch=1.0480e+17 vth0=-8.534e-01+dvthmat \
   voff=-1.640e-01    dvt0=2.2000e+00    dvt1=6.3470e-01 \
   dvt2=5.3690e-02    keta=-7.600e-03 \
 pscbe1=1.0000e+30  pscbe2=1.0000e-06 \
 alpha0=1.0000e-09  alpha1=1.1750e-02   beta0=2.2870e+01 \
  dvt0w=1.0090e-01   dvt1w=7.3400e+04   dvt2w=-6.310e-03 \
     ua=4.1690e-10      ub=1.9050e-18      uc=-3.631e-11 \
u0=1.5460e+02+(1.5460e+02)*dumat \
   dsub=5.0000e-01    eta0=2.4000e-01    etab=-3.917e-03 \
nfactor=1.0000e+00 \
     em=4.1000e+07    pclm=3.5650e+00 \
  drout=5.0000e-01 \
     a0=9.0000e-01      a1=1.4440e-15      a2=5.0780e-01 \
   pvag=4.6400e+00    vsat=1.5480e+05     ags=3.8020e-01      b0=2.1920e-07      b1=0.0000e+00 \
  delta=1.0000e-02 pdiblcb=1.0000e+00 \
pdiblc1=5.6700e+00 pdiblc2=3.0670e-03 \
     w0=-1.500e-07 \
    dlc=-2.929e-08 \
dwc=-3.000e-01*l+1.5000e-07    dwb=-5.244e-09     dwg=-1.100e-08 \
     ll=3.5530e-15      lw=0.0000e+00     lwl=0.0000e+00 \
    lln=1.0000e+00     lwn=1.0000e+00      wl=-5.064e-13 \
     ww=-4.300e-14     wwl=-2.884e-21     wln=1.0000e+00 \
     wr=1.0000e+00     wwn=1.0000e+00 \
     at=3.3000e+04     ute=-1.300e+00 \
    kt1=-4.740e-01     kt2=-5.440e-02    kt1l=-1.600e-08 \
    ua1=0.0000e+00     ub1=-3.802e-19     uc1=0.0000e+00 \
    prt=0.0000e+00 \
   cgso=9.0000e-11    cgdo=9.0000e-11    cgbo=1.9040e-08 \
   cgdl=1.5180e-10    cgsl=1.5180e-10  ckappa=1.0000e-01 \
     cf=0.0000e+00     elm=5.0000e+00 \
  xpart=1.0000e+00     clc=1.0000e-15     cle=6.0000e-01 \
\
   rdsw=5.7750e+03 \
   cdsc=1.2000e-02   cdscb=9.0000e-03   cdscd=1.0000e-03 \
   prwb=1.9620e-02    prwg=-7.244e-03     cit=0.0000e+00 \
tox=8.2640e-09 \
  ngate=0.0000e+00 \
    nlx=3.0770e-08 \
     xl=1.5200e-07      xw=0.0000e+00 \
     af=1.4050e+00      kf=1.8270e-26      ef=1.0000e+00 \
   noia=7.0910e+18    noib=6.0740e+04    noic=3.7790e-13 \
     rd=0.0000e+00      rs=0.0000e+00     rsh=1.5200e+02 \
   minr=1.000e-03 \
    rdc=0.0000e+00     rsc=0.0000e+00 lint=-2.996e-07 \
wint=-6.844e-07   ldif=0.000e+00    hdif=8.0000e-07 \
     xj=3.0000e-07      js=2.8000e-07 \
      n=1.0000e+00 \
  dskip=no          tlev=0           tlevc=0         \
    jsw=3.7000e-13 \
     cj=1.7000e-03    cjsw=4.3750e-10 \
     fc=0.0000e+00    fcsw=0.000e+00 \
     mj=5.4000e-01    mjsw=4.6000e-01 \
     pb=1.0200e+00    pbsw=1.0200e+00     xti=1.9730e+00
ends pmosw_4n

// ----------------------------------------------------------------------

// ----------------------------------------------------------------------
// Owner: austriamicrosystems
// HIT-Kit: Digital
// ************************ SIMULATION PARAMETERS ************************
//  ----------------------------------------------------------------------
//  format    : Spectre (Spectre Direct)
//  model     : MOS BSIM3v3
//  process   : C35
//  revision  : 1.0;
//  extracted : C18069; 28.08.2011; bse (5866)
//  doc#      : Eng-?? REV_0
//  ----------------------------------------------------------------------
//                         WORST CASE SPEED CONDITION
//
//  ----------------------------------------------------------------------
//
inline subckt pmosmw_2n ( d g s b )
parameters w=1.0e-6 l=1.0e-6 nrd=0.0 nrs=0.0 ad=0.0 as=0.0 pd=0.0 ps=0.0 ng=1
+ ws= w
+ ls= l
+ shk=1
+ dvthmat=(mv_pmosmw_2n)*(1.5e-08/sqrt(ls*ws*ng)) dumat=(mu_pmosmw_2n)*(4.3e-9/sqrt(ls*ws*ng))
//
if (modpm==1)
pmosmw_2n ( d g s b ) mosinsub w=ws l=ls nrd=6.0000e-07/ws nrs=6.0000e-07/ws ad=ad as=as pd=pd ps=ps m=ng
else
pmosmw_2n ( d s ) resistor r=1e30
notvalid paramtest errorif=(modpm==0) \
message="
***************************************************
*
* pmosm is not valid in selected process option.
*
***************************************************"
model mosinsub bsim3v3 version=3.2400e+00  type=p  capmod=3.0000e+00 \
 mobmod=1.0000e+00  nqsmod=0.0000e+00  noimod=3.0000e+00 \
   vbox=1.000e+03      k1=6.4060e-01 \
     k2=0.0000e+00      k3=1.8000e+00     k3b=-1.000e+00 \
    nch=9.2600e+16 vth0=-1.186e+00+dvthmat \
   voff=-1.148e-01    dvt0=1.7000e+00    dvt1=4.0100e-01 \
   dvt2=2.0050e-01    keta=2.0800e-02 \
 pscbe1=1.0000e+30  pscbe2=1.0000e-06 \
 alpha0=1.0000e-07  alpha1=3.1620e+00   beta0=4.2260e+01 \
  dvt0w=2.0000e-01   dvt1w=5.0000e+05   dvt2w=-3.200e+00 \
     ua=3.1000e-09      ub=2.2000e-19      uc=-8.318e-11 \
u0=1.9990e+02+(1.9990e+02)*dumat \
   dsub=5.0000e-01    eta0=1.7900e-03    etab=-2.948e-02 \
nfactor=7.0460e-01 \
     em=4.1000e+07    pclm=4.9580e+00 \
  drout=5.0000e-01 \
     a0=1.0000e+00      a1=6.0520e-05      a2=2.2110e-01 \
   pvag=1.0000e+00    vsat=5.0470e+04     ags=1.4450e-01      b0=1.3800e-07      b1=0.0000e+00 \
  delta=1.0000e-02 pdiblcb=6.0000e-02 \
pdiblc1=2.5900e+04 pdiblc2=2.4430e-03 \
     w0=-1.800e-07 \
    dlc=-1.766e-08 \
dwc=-2.953e-01*l+1.4210e-07    dwb=-4.580e-09     dwg=-6.295e-09 \
     ll=0.0000e+00      lw=0.0000e+00     lwl=0.0000e+00 \
    lln=1.0000e+00     lwn=1.0000e+00      wl=-3.685e-12 \
     ww=-3.900e-14     wwl=-4.467e-21     wln=1.0000e+00 \
     wr=1.0000e+00     wwn=1.0000e+00 \
     at=7.9640e+04     ute=-1.492e+00 \
    kt1=-5.480e-01     kt2=-6.000e-02    kt1l=-2.600e-08 \
    ua1=-2.630e-10     ub1=-3.311e-18     uc1=0.0000e+00 \
    prt=0.0000e+00 \
   cgso=1.0010e-10    cgdo=1.0010e-10    cgbo=8.9600e-09 \
   cgdl=1.2060e-10    cgsl=1.2060e-10  ckappa=1.3700e+00 \
     cf=0.0000e+00     elm=5.0000e+00 \
  xpart=1.0000e+00     clc=1.0000e-15     cle=6.0000e-01 \
\
   rdsw=1.0820e+04 \
   cdsc=1.2140e-03   cdscb=2.9450e-04   cdscd=0.0000e+00 \
   prwb=5.0700e-02    prwg=7.0360e-02     cit=5.2590e-05 \
tox=1.6000e-08 \
  ngate=0.0000e+00 \
    nlx=1.2500e-07 \
     xl=3.8000e-07      xw=0.0000e+00 \
     af=1.5640e+00      kf=4.8520e-26      ef=1.0000e+00 \
   noia=1.8720e+18    noib=3.4540e+04    noic=1.2460e-12 \
     rd=0.0000e+00      rs=0.0000e+00     rsh=1.5320e+02 \
   minr=1.000e-03 \
    rdc=0.0000e+00     rsc=0.0000e+00 lint=-1.646e-06 \
wint=-2.751e-06   ldif=0.000e+00    hdif=6.0000e-07 \
     xj=3.0000e-07      js=2.8000e-07 \
      n=1.0000e+00 \
  dskip=no          tlev=0           tlevc=0         \
    jsw=3.7000e-13 \
     cj=1.7000e-03    cjsw=4.3750e-10 \
     fc=0.0000e+00    fcsw=0.000e+00 \
     mj=5.4000e-01    mjsw=4.6000e-01 \
     pb=1.0200e+00    pbsw=1.0200e+00     xti=1.9700e+00
ends pmosmw_2n

// ----------------------------------------------------------------------

// ----------------------------------------------------------------------
// Owner: austriamicrosystems
// HIT-Kit: Digital
// ************************ SIMULATION PARAMETERS ************************
//  ----------------------------------------------------------------------
//  format    : Spectre (Spectre Direct)
//  model     : MOS BSIM3v3
//  process   : C35
//  revision  : 1.0;
//  extracted : C18069; 28.08.2011; bse (5866)
//  doc#      : Eng-?? REV_0
//  ----------------------------------------------------------------------
//                         WORST CASE SPEED CONDITION
//
//  ----------------------------------------------------------------------
//
inline subckt pmosmw_3n ( d g s b )
parameters w=1.0e-6 l=1.0e-6 nrd=0.0 nrs=0.0 ad=0.0 as=0.0 pd=0.0 ps=0.0 ng=1
+ ws= w
+ ls= l
+ shk=1
+ dvthmat=(mv_pmosmw_3n)*(1.5e-08/sqrt(ls*ws*ng)) dumat=(mu_pmosmw_3n)*(4.3e-9/sqrt(ls*ws*ng))
//
if (modpm==1)
pmosmw_3n ( d g s b ) mosinsub w=ws l=ls nrd=6.0000e-07/ws nrs=6.0000e-07/ws ad=ad as=as pd=pd ps=ps m=ng
else
pmosmw_3n ( d s ) resistor r=1e30
notvalid paramtest errorif=(modpm==0) \
message="
***************************************************
*
* pmosm is not valid in selected process option.
*
***************************************************"
model mosinsub bsim3v3 version=3.2400e+00  type=p  capmod=3.0000e+00 \
 mobmod=1.0000e+00  nqsmod=0.0000e+00  noimod=3.0000e+00 \
   vbox=1.000e+03      k1=6.4060e-01 \
     k2=0.0000e+00      k3=1.8000e+00     k3b=-1.000e+00 \
    nch=9.2600e+16 vth0=-1.186e+00+dvthmat \
   voff=-1.148e-01    dvt0=1.7000e+00    dvt1=4.0100e-01 \
   dvt2=2.0050e-01    keta=2.0800e-02 \
 pscbe1=1.0000e+30  pscbe2=1.0000e-06 \
 alpha0=1.0000e-07  alpha1=3.1620e+00   beta0=4.2260e+01 \
  dvt0w=2.0000e-01   dvt1w=5.0000e+05   dvt2w=-3.200e+00 \
     ua=3.1000e-09      ub=2.2000e-19      uc=-1.553e-10 \
u0=1.9990e+02+(1.9990e+02)*dumat \
   dsub=5.0000e-01    eta0=1.7900e-03    etab=-2.948e-02 \
nfactor=7.0460e-01 \
     em=4.1000e+07    pclm=4.9580e+00 \
  drout=5.0000e-01 \
     a0=1.0000e+00      a1=6.0520e-05      a2=2.2110e-01 \
   pvag=-1.500e+00    vsat=4.9050e+04     ags=1.4450e-01      b0=1.3800e-07      b1=0.0000e+00 \
  delta=1.0000e-02 pdiblcb=6.0000e-02 \
pdiblc1=2.6560e+02 pdiblc2=2.6870e-03 \
     w0=-1.800e-07 \
    dlc=-1.766e-08 \
dwc=-2.953e-01*l+1.4210e-07    dwb=-4.580e-09     dwg=-6.295e-09 \
     ll=0.0000e+00      lw=0.0000e+00     lwl=0.0000e+00 \
    lln=1.0000e+00     lwn=1.0000e+00      wl=-2.315e-12 \
     ww=-3.900e-14     wwl=-4.467e-21     wln=1.0000e+00 \
     wr=1.0000e+00     wwn=1.0000e+00 \
     at=7.9640e+04     ute=-1.492e+00 \
    kt1=-5.480e-01     kt2=-6.000e-02    kt1l=-2.600e-08 \
    ua1=-2.630e-10     ub1=-3.311e-18     uc1=0.0000e+00 \
    prt=0.0000e+00 \
   cgso=1.0010e-10    cgdo=1.0010e-10    cgbo=8.9600e-09 \
   cgdl=1.2060e-10    cgsl=1.2060e-10  ckappa=1.3700e+00 \
     cf=0.0000e+00     elm=5.0000e+00 \
  xpart=1.0000e+00     clc=1.0000e-15     cle=6.0000e-01 \
\
   rdsw=1.1340e+04 \
   cdsc=1.2140e-03   cdscb=2.9450e-04   cdscd=0.0000e+00 \
   prwb=-5.503e-02    prwg=1.5470e-02     cit=5.2590e-05 \
tox=1.6000e-08 \
  ngate=0.0000e+00 \
    nlx=1.2500e-07 \
     xl=3.2000e-07      xw=0.0000e+00 \
     af=1.5640e+00      kf=4.8520e-26      ef=1.0000e+00 \
   noia=1.8720e+18    noib=3.4540e+04    noic=1.2460e-12 \
     rd=0.0000e+00      rs=0.0000e+00     rsh=1.5320e+02 \
   minr=1.000e-03 \
    rdc=0.0000e+00     rsc=0.0000e+00 lint=-1.020e-06 \
wint=-1.770e-06   ldif=0.000e+00    hdif=6.0000e-07 \
     xj=3.0000e-07      js=2.8000e-07 \
      n=1.0000e+00 \
  dskip=no          tlev=0           tlevc=0         \
    jsw=3.7000e-13 \
     cj=1.7000e-03    cjsw=4.3750e-10 \
     fc=0.0000e+00    fcsw=0.000e+00 \
     mj=5.4000e-01    mjsw=4.6000e-01 \
     pb=1.0200e+00    pbsw=1.0200e+00     xti=1.9700e+00
ends pmosmw_3n

// ----------------------------------------------------------------------

// ----------------------------------------------------------------------
// Owner: austriamicrosystems
// HIT-Kit: Digital
// ************************ SIMULATION PARAMETERS ************************
//  ----------------------------------------------------------------------
//  format    : Spectre (Spectre Direct)
//  model     : MOS BSIM3v3
//  process   : C35
//  revision  : 1.0;
//  extracted : C18069; 28.08.2011; bse (5866)
//  doc#      : Eng-?? REV_0
//  ----------------------------------------------------------------------
//                         WORST CASE SPEED CONDITION
//
//  ----------------------------------------------------------------------
//
inline subckt pmosmw_4n ( d g s b )
parameters w=1.0e-6 l=1.0e-6 nrd=0.0 nrs=0.0 ad=0.0 as=0.0 pd=0.0 ps=0.0 ng=1
+ ws= w
+ ls= l
+ shk=1
+ dvthmat=(mv_pmosmw_4n)*(1.5e-08/sqrt(ls*ws*ng)) dumat=(mu_pmosmw_4n)*(4.3e-9/sqrt(ls*ws*ng))
//
if (modpm==1)
pmosmw_4n ( d g s b ) mosinsub w=ws l=ls nrd=6.0000e-07/ws nrs=6.0000e-07/ws ad=ad as=as pd=pd ps=ps m=ng
else
pmosmw_4n ( d s ) resistor r=1e30
notvalid paramtest errorif=(modpm==0) \
message="
***************************************************
*
* pmosm is not valid in selected process option.
*
***************************************************"
model mosinsub bsim3v3 version=3.2400e+00  type=p  capmod=3.0000e+00 \
 mobmod=1.0000e+00  nqsmod=0.0000e+00  noimod=3.0000e+00 \
   vbox=1.000e+03      k1=6.4060e-01 \
     k2=0.0000e+00      k3=1.8000e+00     k3b=-1.000e+00 \
    nch=9.2600e+16 vth0=-1.186e+00+dvthmat \
   voff=-1.148e-01    dvt0=1.7000e+00    dvt1=4.0100e-01 \
   dvt2=2.0050e-01    keta=2.0800e-02 \
 pscbe1=1.0000e+30  pscbe2=1.0000e-06 \
 alpha0=1.0000e-07  alpha1=3.1620e+00   beta0=4.2260e+01 \
  dvt0w=2.0000e-01   dvt1w=5.0000e+05   dvt2w=-3.200e+00 \
     ua=3.1000e-09      ub=2.2000e-19      uc=-8.318e-11 \
u0=1.9990e+02+(1.9990e+02)*dumat \
   dsub=5.0000e-01    eta0=1.7900e-03    etab=-2.948e-02 \
nfactor=7.0460e-01 \
     em=4.1000e+07    pclm=4.9580e+00 \
  drout=5.0000e-01 \
     a0=1.0000e+00      a1=6.0520e-05      a2=2.2110e-01 \
   pvag=-1.500e+00    vsat=6.7470e+04     ags=1.4450e-01      b0=1.3800e-07      b1=0.0000e+00 \
  delta=1.0000e-02 pdiblcb=6.0000e-02 \
pdiblc1=2.8350e+01 pdiblc2=3.8950e-03 \
     w0=-1.800e-07 \
    dlc=-1.766e-08 \
dwc=-2.953e-01*l+1.4210e-07    dwb=-4.580e-09     dwg=-6.295e-09 \
     ll=0.0000e+00      lw=0.0000e+00     lwl=0.0000e+00 \
    lln=1.0000e+00     lwn=1.0000e+00      wl=-1.534e-12 \
     ww=-3.900e-14     wwl=-4.467e-21     wln=1.0000e+00 \
     wr=1.0000e+00     wwn=1.0000e+00 \
     at=7.9640e+04     ute=-1.492e+00 \
    kt1=-5.480e-01     kt2=-6.000e-02    kt1l=-2.600e-08 \
    ua1=-2.630e-10     ub1=-3.311e-18     uc1=0.0000e+00 \
    prt=0.0000e+00 \
   cgso=1.0010e-10    cgdo=1.0010e-10    cgbo=8.9600e-09 \
   cgdl=1.2060e-10    cgsl=1.2060e-10  ckappa=1.3700e+00 \
     cf=0.0000e+00     elm=5.0000e+00 \
  xpart=1.0000e+00     clc=1.0000e-15     cle=6.0000e-01 \
\
   rdsw=6.6990e+03 \
   cdsc=1.2140e-03   cdscb=2.9450e-04   cdscd=0.0000e+00 \
   prwb=5.0700e-02    prwg=7.7360e-02     cit=5.2590e-05 \
tox=1.6000e-08 \
  ngate=0.0000e+00 \
    nlx=1.2500e-07 \
     xl=2.3990e-07      xw=0.0000e+00 \
     af=1.5640e+00      kf=4.8520e-26      ef=1.0000e+00 \
   noia=1.8720e+18    noib=3.4540e+04    noic=1.2460e-12 \
     rd=0.0000e+00      rs=0.0000e+00     rsh=1.5320e+02 \
   minr=1.000e-03 \
    rdc=0.0000e+00     rsc=0.0000e+00 lint=-7.278e-07 \
wint=-1.000e-06   ldif=0.000e+00    hdif=6.0000e-07 \
     xj=3.0000e-07      js=2.8000e-07 \
      n=1.0000e+00 \
  dskip=no          tlev=0           tlevc=0         \
    jsw=3.7000e-13 \
     cj=1.7000e-03    cjsw=4.3750e-10 \
     fc=0.0000e+00    fcsw=0.000e+00 \
     mj=5.4000e-01    mjsw=4.6000e-01 \
     pb=1.0200e+00    pbsw=1.0200e+00     xti=1.9700e+00
ends pmosmw_4n

// ----------------------------------------------------------------------

// ----------------------------------------------------------------------
// Owner: austriamicrosystems
// HIT-Kit: Digital
//************************ SIMULATION PARAMETERS ************************
// ----------------------------------------------------------------------
// format    : Spectre
// model     : MODNRF
// process   : CS ADFI
// revision  : 3.1;
// extracted : CSD C64330.04e3; 2002-09; kmo(5966)
// doc#      : ENG-188 REV_5
// ----------------------------------------------------------------------
//                        WORST CASE SPEED CONDITION
// ----------------------------------------------------------------------
//
//  RF CMOS TRANSISTOR MODEL
//
//-----------------------------------------------------------------------
inline subckt modnrf ( d g s b )
parameters w=1.0e-6 l=1.0e-6 nrd=0.0 nrs=0.0 ad=0.0 as=0.0 pd=0.0 ps=0.0 ng=1
+ mmvth_modnrf=0.0 mmu0_modnrf=0.0
+ dvthmat=(mv_modnrf53+mmvth_modnrf)*(0.67e-08/sqrt(l*w*ng)) dumat=(mu_modnrf53+mmu0_modnrf)*(4.9e-9/sqrt(l*w*ng))
// //
if (modnrf==1){
// --------- Gate network ------------------------------
lg  (g 20 ) inductor l=1.000e-15
rg  (20 21 ) resistor r=((6.895e-04/w+4.758e+01 )/ng+(3.726e+05*w+2.740e+00)) isnoisy=yes
//
// --------- Drain network -----------------------------
ldrain ( d 13 ) inductor l=1.000e-15
rdrain ( 13 11 ) resistor r=(3.320e-04/(w*ng)+1.669e-01) isnoisy=yes
//
// --------- Source network -----------------------------
lsource ( s 33 ) inductor l=1.000e-15
rsource ( 33 31 ) resistor r=(3.320e-04/(w*ng)+1.669e-01) isnoisy=yes
//
// --------- Substrate network -------------------------
// Diodes are for n-type or p-type MOS transistors
//
djdb  ( 12 11 ) bulk_diode area=ad*ng perim=pd*ng
djsb  ( 32 31 ) bulk_diode area=as*ng perim=ps*ng
//
rsub1 ( 12 b ) resistor r=((0.000e+00/w+0.000e+00)/ng+(9.524e+06*w+(4.156e+01))) isnoisy=yes
rsub2 ( 32 b ) resistor r=((0.000e+00/w+0.000e+00)/ng+(9.524e+06*w+(4.156e+01))) isnoisy=yes
//
// --------- Ideal mos transistor ----------------------
modnrf ( 11 21 31 b ) mosinsub l=l w=w*ng ad=0.0 as=0.0 pd=0.0 ps=0.0 nrd=0 nrs=0
}else
modnrf ( d s ) resistor r=1e30
notvalid paramtest errorif=(modnrf==0) \
message="
***************************************************
*
* nmosrf is not valid in selected process option.
*
***************************************************"
// Intrinsic MOS transistor
model mosinsub bsim3v3 version=3.1 type=n  capmod=2.0000e+00 \
 mobmod=1.0000e+00  nqsmod=0.0000e+00  noimod=3 \
   vbox=1.000e+03      k1=7.5607e-01 \
     k2=-1.162e-02      k3=-1.715e+00     k3b=6.3250e-01 \
    nch=2.7470e+17 vth0=5.3550e-01+dvthmat \
   voff=-5.719e-02    dvt0=2.2270e+01    dvt1=1.0510e+00 \
   dvt2=3.3930e-03    keta=-6.207e-04 \
 pscbe1=2.7560e+08  pscbe2=9.6450e-06 \
 alpha0=0.0000e+00   beta0=3.0000e+01 \
  dvt0w=0.0000e+00   dvt1w=0.0000e+00   dvt2w=0.0000e+00 \
     ua=1.0000e-12      ub=4.8510e-18      uc=5.7560e-11 \
u0=6.1140e+02+(6.1140e+02)*dumat \
   dsub=5.0000e-01    eta0=3.0850e-02    etab=-3.947e-02 \
nfactor=1.1190e-01 \
     em=4.1000e+07    pclm=1.5270e+00 \
  drout=5.0000e-01 \
     a0=2.2080e+00      a1=0.0000e+00      a2=1.0000e+00 \
   pvag=0.0000e+00    vsat=7.5800e+04     ags=2.4900e-01      b0=-1.765e-08      b1=0.0000e+00 \
  delta=1.0000e-02 pdiblcb=2.5830e-01 \
pdiblc1=1.0760e-01 pdiblc2=1.4530e-03 \
     w0=1.1840e-07 \
    dlc=6.6050e-08 \
    dwc=2.6760e-08     dwb=0.0000e+00     dwg=0.0000e+00 \
     ll=0.000e+00      lw=0.000e+00     lwl=0.000e+00 \
    lln=1.000e+00     lwn=1.000e+00      wl=0.0000e+00 \
     ww=0.0000e+00     wwl=0.0000e+00     wln=1.0000e+00 \
     wr=1.0000e+00     wwn=1.0000e+00 \
     at=3.3000e+04     ute=-1.800e+00 \
    kt1=-3.302e-01     kt2=2.2000e-02    kt1l=0.0000e+00 \
    ua1=0.0000e+00     ub1=0.0000e+00     uc1=0.0000e+00 \
    prt=0.0000e+00 \
   cgso=1.8730e-10    cgdo=1.8730e-10    cgbo=1.2000e-10 \
   cgdl=1.3480e-10    cgsl=1.3480e-10  ckappa=6.0000e-01 \
     cf=0.0000e+00     elm=5.0000e+00 \
  xpart=1.0000e+00     clc=1.0000e-15     cle=6.0000e-01 \
\
   rdsw=0.0000e+00 \
   cdsc=0.0000e+00   cdscb=0.0000e+00   cdscd=8.4480e-05 \
   prwb=0.0000e+00    prwg=0.0000e+00     cit=1.0000e-03 \
tox=8.1000e-09 \
  ngate=0.0000e+00 \
    nlx=1.9180e-07 \
     xl=5.0000e-08      xw=-5.000e-08 \
     af=1.3760e+00      kf=3.3960e-26      ef=1.0000e+00 \
   noia=1.3990e+20    noib=2.7070e+05    noic=-4.680e-12 \
     rd=0.0000e+00      rs=0.0000e+00     rsh=8.2000e+01 \
   minr=1.000e-03 \
    rdc=0.0000e+00     rsc=0.0000e+00 lint=8.2850e-09 \
wint=2.6760e-08   ldif=0.000e+00    hdif=6.0000e-07 \
     xj=3.0000e-07      js=5.1000e-07 \
      n=1.0000e+00 \
  dskip=no          tlev=0           tlevc=0         \
    jsw=0.0000e+00 \
     cj=0.0000e+00    cjsw=0.0000e+00 \
     fc=0.0000e+00    fcsw=0.000e+00 \
     mj=3.1000e-01    mjsw=1.9000e-01 \
     pb=6.9000e-01    pbsw=6.9000e-01
// Bulk Diode Model
model bulk_diode diode level=1 dskip=no \
     is=5.100e-07      isw=0.600e-12       n=1.0000000       ns=1.0000000   \
    cjo=1.580e-03       m=3.100e-01 \
    cjsw=0.000e+00       mjsw=2.011E-01 \
     fc=0.000e+00      tt=0.000e+00      vj=6.900e-01      vjsw=6.672E-01  \
     kf=0.000e+00      eg=1.11e+00     xti=2.026e+00      af=1.000e+00
ends modnrf
// ----------------------------------------------------------------------
// ----------------------------------------------------------------------
// Owner: austriamicrosystems
// HIT-Kit: Digital
//************************ SIMULATION PARAMETERS ************************
// ----------------------------------------------------------------------
// format    : Spectre
// model     : MODPRF
// process   : C/B/S 35
// revision  : 3.1;
// extracted : C35B3 B11634.L1 04PA3; 2002-09; kmo(5966)
// doc#      : ENG-188 REV_5
// ----------------------------------------------------------------------
//                        WORST CASE SPEED CONDITION
// ----------------------------------------------------------------------
//
//  RF CMOS TRANSISTOR MODEL
//
//-----------------------------------------------------------------------
inline subckt modprf ( d g s b )
parameters w=1.0e-6 l=1.0e-6 nrd=0.0 nrs=0.0 ad=0.0 as=0.0 pd=0.0 ps=0.0 ng=1
+ mmvth_modprf=0.0 mmu0_modprf=0.0
+ dvthmat=(mv_modprf53+mmvth_modprf)*(1.03e-08/sqrt(l*w*ng)) dumat=(mu_modprf53+mmu0_modprf)*(7.1e-9/sqrt(l*w*ng))
// //
if (modprf==1){
// --------- Gate network ------------------------------
lg  (g 20 ) inductor l=1.000e-15
rg  (20 21 ) resistor r=((-5.800e-04/w+2.884e+02 )/ng+(-5.394e+05*w+1.596e+00)) isnoisy=yes
//
// --------- Drain network -----------------------------
ldrain ( d 13 ) inductor l=1.000e-15
rdrain ( 13 11 ) resistor r=(8.051e-04/(w*ng)+1.731e+00) isnoisy=yes
//
// --------- Source network -----------------------------
lsource ( s 33 ) inductor l=1.000e-15
rsource ( 33 31 ) resistor r=(8.051e-04/(w*ng)+1.731e+00) isnoisy=yes
//
// --------- Substrate network -------------------------
// Diodes are for n-type or p-type MOS transistors
//
djdb  ( 11 12 ) bulk_diode area=ad*ng perim=pd*ng
djsb  ( 31 32 ) bulk_diode area=as*ng perim=ps*ng
//
rsub1 ( 12 b ) resistor r=((1.064e-04/w+1.682e+02)/ng+(1.724e+06*w+(-2.292e+00))) isnoisy=yes
rsub2 ( 32 b ) resistor r=((1.064e-04/w+1.682e+02)/ng+(1.724e+06*w+(-2.292e+00))) isnoisy=yes
//
// --------- Ideal mos transistor ----------------------
modprf ( 11 21 31 b ) mosinsub l=l w=w*ng ad=0.0 as=0.0 pd=0.0 ps=0.0 nrd=0 nrs=0
}else
modprf ( d s ) resistor r=1e30
notvalid paramtest errorif=(modprf==0) \
message="
***************************************************
*
* pmosrf is not valid in selected process option.
*
***************************************************"
// Intrinsic MOS transistor
model mosinsub bsim3v3 version=3.1 type=p  capmod=2.0000e+00 \
 mobmod=1.0000e+00  nqsmod=0.0000e+00  noimod=3 \
   vbox=1.000e+03      k1=-3.435e-01 \
     k2=2.3024e-01      k3=1.1030e+01     k3b=-7.580e-01 \
    nch=1.8000e+17 vth0=-8.419e-01+dvthmat \
   voff=-1.170e-01    dvt0=1.6500e+00    dvt1=3.8680e-01 \
   dvt2=1.6590e-02    keta=-1.440e-02 \
 pscbe1=5.0000e+09  pscbe2=1.0000e-04 \
 alpha0=0.0000e+00   beta0=3.0000e+01 \
  dvt0w=1.8790e-01   dvt1w=7.3350e+04   dvt2w=-6.312e-03 \
     ua=5.3940e-10      ub=3.9760e-19      uc=1.0000e-20 \
u0=1.2040e+02+(1.2040e+02)*dumat \
   dsub=5.0000e-01    eta0=2.4800e-01    etab=-3.917e-03 \
nfactor=1.2140e+00 \
     em=4.1000e+07    pclm=1.8290e+00 \
  drout=5.0000e-01 \
     a0=5.8500e-01      a1=0.0000e+00      a2=1.0000e+00 \
   pvag=0.0000e+00    vsat=4.8240e+04     ags=2.4680e-01      b0=8.8320e-08      b1=0.0000e+00 \
  delta=1.0000e-02 pdiblcb=1.0000e+00 \
pdiblc1=1.0000e-04 pdiblc2=1.0000e-20 \
     w0=1.0000e-10 \
    dlc=5.6730e-08 \
    dwc=3.4490e-08     dwb=0.0000e+00     dwg=0.0000e+00 \
     ll=0.000e+00      lw=0.000e+00     lwl=0.000e+00 \
    lln=1.000e+00     lwn=1.000e+00      wl=0.0000e+00 \
     ww=1.8940e-16     wwl=-1.981e-21     wln=1.0000e+00 \
     wr=1.0000e+00     wwn=1.0400e+00 \
     at=3.3000e+04     ute=-1.300e+00 \
    kt1=-5.403e-01     kt2=2.2000e-02    kt1l=0.0000e+00 \
    ua1=0.0000e+00     ub1=0.0000e+00     uc1=0.0000e+00 \
    prt=0.0000e+00 \
   cgso=1.0000e-12    cgdo=1.0000e-12    cgbo=1.2000e-10 \
   cgdl=2.8980e-10    cgsl=2.8980e-10  ckappa=6.0000e-01 \
     cf=0.0000e+00     elm=5.0000e+00 \
  xpart=1.0000e+00     clc=1.0000e-15     cle=6.0000e-01 \
\
   rdsw=0.0000e+00 \
   cdsc=2.5890e-03   cdscb=2.9430e-04   cdscd=4.3700e-04 \
   prwb=-9.731e-02    prwg=1.4770e-01     cit=0.0000e+00 \
tox=8.1000e-09 \
  ngate=0.0000e+00 \
    nlx=1.7700e-07 \
     xl=4.0000e-08      xw=-7.000e-08 \
     af=1.4050e+00      kf=1.8270e-26      ef=1.0000e+00 \
   noia=7.0910e+18    noib=6.0740e+04    noic=3.7790e-13 \
     rd=0.0000e+00      rs=0.0000e+00     rsh=1.2900e+02 \
   minr=1.000e-03 \
    rdc=0.0000e+00     rsc=0.0000e+00 lint=-1.164e-08 \
wint=3.4490e-08   ldif=0.000e+00    hdif=8.0000e-07 \
     xj=3.0000e-07      js=2.8000e-07 \
      n=1.0000e+00 \
  dskip=no          tlev=0           tlevc=0         \
    jsw=3.7000e-13 \
     cj=0.0000e+00    cjsw=0.0000e+00 \
     fc=0.0000e+00    fcsw=0.000e+00 \
     mj=5.6000e-01    mjsw=4.3000e-01 \
     pb=1.0200e+00    pbsw=1.0200e+00     xti=1.9700e+00
// Bulk Diode Model
model bulk_diode diode level=1 dskip=no \
     is=2.800e-07      isw=3.700e-13       n=1.0000000       ns=1.0000000   \
    cjo=1.526e-03       m=1.176e-01 \
    cjsw=0.000e+00       mjsw=4.300e-01 \
     fc=0.000e+00      tt=0.000e+00      vj=1.020e+00      vjsw=1.020e+00  \
     kf=0.000e+00      eg=1.11e+00     xti=1.973e+00      af=1.000e+00
ends modprf
// ----------------------------------------------------------------------
//-------------- END OF Section ------------------
endsection
section cmoswo
//
// ----------------------------------------------------------------------
// Owner: austriamicrosystems
// HIT-Kit: Digital
// ************************ SIMULATION PARAMETERS ************************
//  ----------------------------------------------------------------------
//  format    : Spectre (Spectre Direct)
//  model     : MOS BSIM3v3
//  process   : C35
//  revision  : 4.0;
//  extracted : B10866 ; 2002-12; ese(5487)
//  doc#      : ENG-182 REV_6
//  ----------------------------------------------------------------------
//                         WORST CASE ONE CONDITION
//
//  ----------------------------------------------------------------------
//
inline subckt modn ( d g s b )
parameters w=1.0e-6 l=1.0e-6 nrd=0.0 nrs=0.0 ad=0.0 as=0.0 pd=0.0 ps=0.0 ng=1
+ ws= w
+ ls= l
+ shk=1
+ dvthmat=(mv_modn)*(0.67e-08/sqrt(ls*ws*ng)) dumat=(mu_modn)*(4.9e-9/sqrt(ls*ws*ng))
//
if (modn==1)
modn ( d g s b ) mosinsub w=ws l=ls nrd=nrd nrs=nrs ad=ad as=as pd=pd ps=ps m=ng
else
modn ( d s ) resistor r=1e30
notvalid paramtest errorif=(modn==0) \
message="
***************************************************
*
* nmos is not valid in selected process option.
*
***************************************************"
model mosinsub bsim3v3 version=3.2400e+00  type=n  capmod=2.0000e+00 \
 mobmod=1.0000e+00  nqsmod=0.0000e+00  noimod=3 \
   vbox=1.000e+03      k1=3.8018e-01 \
     k2=5.0050e-02      k3=-1.136e+00     k3b=-4.399e-01 \
    nch=2.1280e+17 vth0=3.5790e-01+dvthmat \
   voff=-8.925e-02    dvt0=5.0000e+01    dvt1=1.0390e+00 \
   dvt2=-8.375e-03    keta=2.0320e-02 \
 pscbe1=1.0000e+30  pscbe2=1.0000e-06 \
 alpha0=2.6000e-06  alpha1=5.0000e+00   beta0=2.1000e+01 \
  dvt0w=1.0890e-01   dvt1w=6.6710e+04   dvt2w=-1.352e-02 \
     ua=4.7050e-12      ub=2.1370e-18      uc=1.0000e-20 \
u0=5.0020e+02+(5.0020e+02)*dumat \
   dsub=5.0000e-01    eta0=1.4150e-02    etab=-1.221e-01 \
nfactor=4.1360e-01 \
     em=4.1000e+07    pclm=6.9480e-01 \
  drout=5.0000e-01 \
     a0=2.5410e+00      a1=0.0000e+00      a2=1.0000e+00 \
   pvag=0.0000e+00    vsat=1.3380e+05     ags=2.4080e-01      b0=4.3010e-09      b1=0.0000e+00 \
  delta=1.4420e-02 pdiblcb=3.2220e-01 \
pdiblc1=3.5710e-01 pdiblc2=2.0650e-03 \
     w0=2.6730e-07 \
    dlc=3.0000e-08 \
    dwc=9.4030e-08     dwb=0.0000e+00     dwg=0.0000e+00 \
     ll=0.000e+00      lw=0.000e+00     lwl=0.000e+00 \
    lln=1.000e+00     lwn=1.000e+00      wl=0.0000e+00 \
     ww=-1.297e-14     wwl=-9.411e-21     wln=1.0000e+00 \
     wr=1.0000e+00     wwn=1.0000e+00 \
     at=3.3000e+04     ute=-1.800e+00 \
    kt1=-3.302e-01     kt2=2.2000e-02    kt1l=0.0000e+00 \
    ua1=0.0000e+00     ub1=0.0000e+00     uc1=0.0000e+00 \
    prt=0.0000e+00 \
   cgso=1.2000e-10    cgdo=1.2000e-10    cgbo=1.1000e-10 \
   cgdl=1.2033e-10    cgsl=1.2033e-10  ckappa=6.0000e-01 \
     cf=0.0000e+00     elm=5.0000e+00 \
  xpart=1.0000e+00     clc=1.0000e-15     cle=6.0000e-01 \
   noff=1.0000e+00  voffcv=0.0000e+00 \
   rdsw=3.4490e+02 \
   cdsc=0.0000e+00   cdscb=1.5000e-03   cdscd=1.0000e-03 \
   prwb=-2.416e-01    prwg=0.0000e+00     cit=4.4410e-04 \
tox=7.6000e-09 \
  ngate=0.0000e+00 \
    nlx=1.8880e-07 \
     xl=-5.000e-08      xw=-2.500e-08 \
     af=1.3760e+00      kf=3.3960e-26      ef=1.0000e+00 \
   noia=1.3990e+20    noib=2.7070e+05    noic=-4.680e-12 \
     rd=0.0000e+00      rs=0.0000e+00     rsh=5.5000e+01 \
   minr=1.000e-03 \
    rdc=0.0000e+00     rsc=0.0000e+00 lint=-5.005e-08 \
wint=9.4030e-08   ldif=0.000e+00    hdif=8.0000e-07 \
     xj=3.0000e-07      js=5.1000e-07 \
      n=1.0000e+00 \
  dskip=no          tlev=0           tlevc=0         \
    jsw=6.0000e-13 \
     cj=8.2700e-04    cjsw=2.2000e-10 \
     fc=0.0000e+00    fcsw=0.000e+00 \
     mj=3.4000e-01    mjsw=2.3000e-01 \
     pb=6.9000e-01    pbsw=6.9000e-01     xti=2.0260e+00
ends modn

// ----------------------------------------------------------------------
// ----------------------------------------------------------------------
// Owner: austriamicrosystems
// HIT-Kit: Digital
// ************************ SIMULATION PARAMETERS ************************
//  ----------------------------------------------------------------------
//  format    : Spectre (Spectre Direct)
//  model     : MOS BSIM3v3
//  process   : C35
//  revision  : 4.1;
//  extracted : B11004 ; 2002-12; ese(5487)
//  doc#      : ENG-182 REV_6
//  ----------------------------------------------------------------------
//                         WORST CASE ONE CONDITION
//
//  ----------------------------------------------------------------------
//
inline subckt modnm ( d g s b )
parameters w=1.0e-6 l=1.0e-6 nrd=0.0 nrs=0.0 ad=0.0 as=0.0 pd=0.0 ps=0.0 ng=1
+ ws= w
+ ls= l
+ shk=1
+ dvthmat=(mv_modnm)*(1.03e-08/sqrt(ls*ws*ng)) dumat=(mu_modnm)*(3.5e-9/sqrt(ls*ws*ng))
//
if (modnm==1)
modnm ( d g s b ) mosinsub w=ws l=ls nrd=nrd nrs=nrs ad=ad as=as pd=pd ps=ps m=ng
else
modnm ( d s ) resistor r=1e30
notvalid paramtest errorif=(modnm==0) \
message="
***************************************************
*
* nmosm is not valid in selected process option.
*
***************************************************"
model mosinsub bsim3v3 version=3.2400e+00  type=n  capmod=2.0000e+00 \
 mobmod=1.0000e+00  nqsmod=0.0000e+00  noimod=3 \
   vbox=1.000e+03      k1=6.1495e-01 \
     k2=1.2866e-01      k3=-3.776e+00     k3b=-7.691e-02 \
    nch=2.0710e+17 vth0=6.2950e-01+dvthmat \
   voff=-8.295e-02    dvt0=3.0000e+01    dvt1=1.5280e+00 \
   dvt2=2.5290e-02    keta=3.5850e-02 \
 pscbe1=1.0000e+30  pscbe2=1.0000e-06 \
 alpha0=7.7410e-09  alpha1=3.9830e-01   beta0=2.0700e+01 \
  dvt0w=-5.000e+00   dvt1w=2.5780e+06   dvt2w=5.1050e-02 \
     ua=4.7080e-10      ub=1.4700e-18      uc=-4.342e-11 \
u0=6.1370e+02+(6.1370e+02)*dumat \
   dsub=5.0000e-01    eta0=3.7950e-02    etab=-7.653e-04 \
nfactor=8.5730e-01 \
     em=4.1000e+07    pclm=2.1250e-01 \
  drout=5.0000e-01 \
     a0=2.0640e+00      a1=0.0000e+00      a2=1.0000e+00 \
   pvag=0.0000e+00    vsat=1.0780e+05     ags=1.0790e-01      b0=-1.493e-07      b1=0.0000e+00 \
  delta=1.0000e-02 pdiblcb=5.1860e-01 \
pdiblc1=1.0000e-04 pdiblc2=5.4580e-04 \
     w0=1.6170e-07 \
    dlc=1.0000e-07 \
    dwc=1.6230e-07     dwb=0.0000e+00     dwg=0.0000e+00 \
     ll=0.000e+00      lw=0.000e+00     lwl=0.000e+00 \
    lln=1.000e+00     lwn=1.000e+00      wl=0.0000e+00 \
     ww=-5.117e-14     wwl=-5.704e-21     wln=1.0000e+00 \
     wr=1.0000e+00     wwn=1.0000e+00 \
     at=3.3000e+04     ute=-1.760e+00 \
    kt1=-4.502e-01     kt2=2.2000e-02    kt1l=0.0000e+00 \
    ua1=0.0000e+00     ub1=0.0000e+00     uc1=0.0000e+00 \
    prt=0.0000e+00 \
   cgso=1.0800e-10    cgdo=1.0800e-10    cgbo=1.1000e-10 \
   cgdl=2.0900e-10    cgsl=2.0900e-10  ckappa=6.0000e-01 \
     cf=0.0000e+00     elm=5.0000e+00 \
  xpart=1.0000e+00     clc=1.0000e-15     cle=6.0000e-01 \
   noff=1.0000e+00  voffcv=0.0000e+00 \
   rdsw=1.3900e+03 \
   cdsc=0.0000e+00   cdscb=-1.500e-03   cdscd=0.0000e+00 \
   prwb=-6.740e-02    prwg=0.0000e+00     cit=0.0000e+00 \
tox=1.5000e-08 \
  ngate=0.0000e+00 \
    nlx=2.2830e-07 \
     xl=-6.000e-08      xw=-5.000e-08 \
     af=1.3580e+00      kf=3.4460e-26      ef=1.0000e+00 \
   noia=1.7020e+20    noib=5.4630e+05    noic=-1.400e-11 \
     rd=0.0000e+00      rs=0.0000e+00     rsh=5.5000e+01 \
   minr=1.000e-03 \
    rdc=0.0000e+00     rsc=0.0000e+00 lint=1.2250e-07 \
wint=1.6230e-07   ldif=0.000e+00    hdif=6.0000e-07 \
     xj=3.0000e-07      js=5.1000e-07 \
      n=1.0000e+00 \
  dskip=no          tlev=0           tlevc=0         \
    jsw=6.0000e-13 \
     cj=8.2700e-04    cjsw=2.2000e-10 \
     fc=0.0000e+00    fcsw=0.000e+00 \
     mj=3.4000e-01    mjsw=2.3000e-01 \
     pb=6.9000e-01    pbsw=6.9000e-01     xti=2.0260e+00
ends modnm

// ----------------------------------------------------------------------

// ----------------------------------------------------------------------
// Owner: austriamicrosystems
// HIT-Kit: Digital
// ************************ SIMULATION PARAMETERS ************************
//  ----------------------------------------------------------------------
//  format    : Spectre (Spectre Direct)
//  model     : MOS BSIM3v3
//  process   : C35
//  revision  : 5.0;
//  extracted : B27167L1W5C45; 15-04-2007; bse (5866)
//  doc#      : Eng-182 REV_6
//  ----------------------------------------------------------------------
//                         WORST CASE ONE CONDITION
//
//  ----------------------------------------------------------------------
//
inline subckt modnl ( d g s b )
parameters w=1.0e-6 l=1.0e-6 nrd=0.0 nrs=0.0 ad=0.0 as=0.0 pd=0.0 ps=0.0 ng=1
+ ws= w
+ ls= l
+ shk=1
+ dvthmat=(mv_modnl)*(0.67e-08/sqrt(ls*ws*ng)) dumat=(mu_modnl)*(4.9e-9/sqrt(ls*ws*ng))
//
if (modnl==1)
modnl ( d g s b ) mosinsub w=ws l=ls nrd=8.0000e-07/ws nrs=8.0000e-07/ws ad=ad as=as pd=pd ps=ps m=ng
else
modnl ( d s ) resistor r=1e30
notvalid paramtest errorif=(modnl==0) \
message="
***************************************************
*
* nmosl is not valid in selected process option.
*
***************************************************"
model mosinsub bsim3v3 version=3.2400e+00  type=n  capmod=2.0000e+00 \
 mobmod=1.0000e+00  nqsmod=0.0000e+00  noimod=3.0000e+00 \
   vbox=1.000e+03      k1=5.4000e-01 \
     k2=0.0000e+00      k3=7.6040e+00     k3b=0.0000e+00 \
    nch=1.6340e+17 vth0=3.4200e-01+dvthmat \
   voff=-8.000e-02    dvt0=1.2570e+01    dvt1=8.1290e-01 \
   dvt2=2.2200e-15    keta=-2.800e-03 \
 pscbe1=1.0000e+30  pscbe2=1.0000e-06 \
 alpha0=1.9000e-06  alpha1=1.0000e+00   beta0=2.0000e+01 \
  dvt0w=0.0000e+00   dvt1w=1.6970e+06   dvt2w=2.5060e-01 \
     ua=1.0000e-12      ub=2.1880e-18      uc=7.2440e-11 \
u0=4.6840e+02+(4.6840e+02)*dumat \
   dsub=5.0000e-01    eta0=5.1580e-02    etab=-6.600e-02 \
nfactor=1.0000e+00 \
     em=4.1000e+07    pclm=1.2650e+00 \
  drout=5.0000e-01 \
     a0=1.7080e+00      a1=0.0000e+00      a2=1.0000e+00 \
   pvag=3.1500e-01    vsat=9.4190e+04     ags=3.1620e-01      b0=2.6240e-08      b1=0.0000e+00 \
  delta=1.0000e-03 pdiblcb=3.6000e-01 \
pdiblc1=1.2970e-01 pdiblc2=1.9500e-03 \
     w0=2.5000e-06 \
    dlc=3.0000e-08 \
    dwc=9.5120e-08     dwb=0.0000e+00     dwg=-7.686e-09 \
     ll=6.3200e-15      lw=0.0000e+00     lwl=0.0000e+00 \
    lln=1.0000e+00     lwn=1.0000e+00      wl=0.0000e+00 \
     ww=-2.855e-14     wwl=-4.365e-21     wln=1.0000e+00 \
     wr=1.0000e+00     wwn=1.0000e+00 \
     at=1.0000e+04     ute=-1.700e+00 \
    kt1=-3.400e-01     kt2=-4.840e-02    kt1l=0.0000e+00 \
    ua1=0.0000e+00     ub1=0.0000e+00     uc1=0.0000e+00 \
    prt=0.0000e+00 \
   cgso=1.2000e-11    cgdo=1.2000e-11    cgbo=1.1000e-10 \
   cgdl=3.1667e-10    cgsl=3.1667e-10  ckappa=1.7010e+00 \
     cf=0.0000e+00     elm=5.0000e+00 \
  xpart=1.0000e+00     clc=1.0000e-15     cle=6.0000e-01 \
\
   rdsw=4.4670e+02 \
   cdsc=1.0000e-09   cdscb=0.0000e+00   cdscd=0.0000e+00 \
   prwb=0.0000e+00    prwg=1.9050e-02     cit=0.0000e+00 \
tox=7.6000e-09 \
  ngate=0.0000e+00 \
    nlx=1.4300e-07 \
     xl=-1.780e-08      xw=-7.980e-09 \
     af=1.4940e+00      kf=6.9860e-26      ef=1.0000e+00 \
   noia=9.8640e+19    noib=1.7020e+05    noic=-2.723e-12 \
     rd=0.0000e+00      rs=0.0000e+00     rsh=6.5000e+01 \
   minr=1.000e-03 \
    rdc=0.0000e+00     rsc=0.0000e+00 lint=-6.902e-09 \
wint=9.5120e-08   ldif=0.000e+00    hdif=8.0000e-07 \
     xj=3.0000e-07      js=5.1000e-07 \
      n=1.0000e+00 \
  dskip=no          tlev=0           tlevc=0         \
    jsw=6.0000e-13 \
     cj=6.6400e-04    cjsw=2.0000e-10 \
     fc=0.0000e+00    fcsw=0.000e+00 \
     mj=3.4000e-01    mjsw=2.3000e-01 \
     pb=6.9000e-01    pbsw=6.9000e-01     xti=2.0300e+00
ends modnl

// ----------------------------------------------------------------------

// ----------------------------------------------------------------------
// Owner: austriamicrosystems
// HIT-Kit: Digital
// ************************ SIMULATION PARAMETERS ************************
//  ----------------------------------------------------------------------
//  format    : Spectre (Spectre Direct)
//  model     : MOS BSIM3v3
//  process   : C35
//  revision  : 5.0;
//  extracted : B27167L1W5C45; 15-04-2007; bse (5866)
//  doc#      : Eng-182 REV_6
//  ----------------------------------------------------------------------
//                         WORST CASE ONE CONDITION
//
//  ----------------------------------------------------------------------
//
inline subckt modnml ( d g s b )
parameters w=1.0e-6 l=1.0e-6 nrd=0.0 nrs=0.0 ad=0.0 as=0.0 pd=0.0 ps=0.0 ng=1
+ ws= w
+ ls= l
+ shk=1
+ dvthmat=(mv_modnml)*(0.95e-08/sqrt(ls*ws*ng)) dumat=(mu_modnml)*(3.5e-9/sqrt(ls*ws*ng))
//
if (modnml==1)
modnml ( d g s b ) mosinsub w=ws l=ls nrd=6.0000e-07/ws nrs=6.0000e-07/ws ad=ad as=as pd=pd ps=ps m=ng
else
modnml ( d s ) resistor r=1e30
notvalid paramtest errorif=(modnml==0) \
message="
***************************************************
*
* nmosml is not valid in selected process option.
*
***************************************************"
model mosinsub bsim3v3 version=3.2400e+00  type=n  capmod=2.0000e+00 \
 mobmod=1.0000e+00  nqsmod=0.0000e+00  noimod=3.0000e+00 \
   vbox=1.000e+03      k1=9.8000e-01 \
     k2=0.0000e+00      k3=-1.456e+00     k3b=-7.244e-01 \
    nch=1.1770e+17 vth0=4.7940e-01+dvthmat \
   voff=-8.684e-02    dvt0=1.6010e+01    dvt1=1.0610e+00 \
   dvt2=4.5970e-02    keta=1.9180e-02 \
 pscbe1=1.0000e+30  pscbe2=1.0000e-06 \
 alpha0=1.6220e-08  alpha1=1.3800e-01   beta0=2.1000e+01 \
  dvt0w=0.0000e+00   dvt1w=3.0990e+06   dvt2w=4.5170e-02 \
     ua=1.0000e-12      ub=2.2910e-18      uc=6.9180e-11 \
u0=5.5070e+02+(5.5070e+02)*dumat \
   dsub=5.0000e-01    eta0=5.1290e-02    etab=-5.126e-03 \
nfactor=9.6050e-01 \
     em=4.1000e+07    pclm=1.1380e+00 \
  drout=5.0000e-01 \
     a0=1.0460e+00      a1=0.0000e+00      a2=1.0000e+00 \
   pvag=5.0000e-02    vsat=8.4420e+04     ags=1.2000e-01      b0=0.0000e+00      b1=0.0000e+00 \
  delta=1.8640e-03 pdiblcb=9.7980e-01 \
pdiblc1=6.1030e-06 pdiblc2=7.2440e-04 \
     w0=3.3160e-08 \
    dlc=1.0000e-07 \
    dwc=1.1660e-07     dwb=5.8200e-09     dwg=-1.000e-09 \
     ll=-9.793e-15      lw=0.0000e+00     lwl=0.0000e+00 \
    lln=1.0000e+00     lwn=1.0000e+00      wl=0.0000e+00 \
     ww=-4.017e-14     wwl=-1.380e-21     wln=1.0000e+00 \
     wr=1.0000e+00     wwn=1.0000e+00 \
     at=4.3550e+04     ute=-1.720e+00 \
    kt1=-4.500e-01     kt2=-6.560e-02    kt1l=0.0000e+00 \
    ua1=2.7540e-10     ub1=0.0000e+00     uc1=0.0000e+00 \
    prt=2.0000e+02 \
   cgso=1.0000e-12    cgdo=1.0000e-12    cgbo=1.1000e-10 \
   cgdl=3.9867e-10    cgsl=3.9867e-10  ckappa=1.9040e+00 \
     cf=0.0000e+00     elm=5.0000e+00 \
  xpart=1.0000e+00     clc=1.0000e-15     cle=6.0000e-01 \
\
   rdsw=1.1940e+03 \
   cdsc=2.4000e-04   cdscb=-7.468e-04   cdscd=0.0000e+00 \
   prwb=5.2110e-02    prwg=-5.443e-02     cit=0.0000e+00 \
tox=1.5000e-08 \
  ngate=1.0000e+00 \
    nlx=2.3690e-07 \
     xl=-1.208e-08      xw=-1.100e-08 \
     af=1.4000e+00      kf=3.7700e-26      ef=1.0000e+00 \
   noia=1.5360e+20    noib=3.5840e+05    noic=-1.304e-11 \
     rd=0.0000e+00      rs=0.0000e+00     rsh=6.5000e+01 \
   minr=1.000e-03 \
    rdc=0.0000e+00     rsc=0.0000e+00 lint=1.1900e-07 \
wint=1.1660e-07   ldif=0.000e+00    hdif=6.0000e-07 \
     xj=3.0000e-07      js=5.1000e-07 \
      n=1.0000e+00 \
  dskip=no          tlev=0           tlevc=0         \
    jsw=6.0000e-13 \
     cj=6.6600e-04    cjsw=2.0000e-10 \
     fc=0.0000e+00    fcsw=0.000e+00 \
     mj=3.4000e-01    mjsw=2.3000e-01 \
     pb=6.9000e-01    pbsw=6.9000e-01     xti=2.0300e+00
ends modnml

// ----------------------------------------------------------------------
// ----------------------------------------------------------------------
// Owner: austriamicrosystems
// HIT-Kit: Digital
// ************************ SIMULATION PARAMETERS ************************
//  ----------------------------------------------------------------------
//  format    : Spectre (Spectre Direct)
//  model     : MOS BSIM3v3
//  process   : C35
//  revision  : 4.1;
//  extracted : C64685 ; 2002-12; ese(5487)
//  doc#      : ENG-182 REV_6
//  ----------------------------------------------------------------------
//                         WORST CASE ONE CONDITION
//
//  ----------------------------------------------------------------------
//
inline subckt modpm ( d g s b )
parameters w=1.0e-6 l=1.0e-6 nrd=0.0 nrs=0.0 ad=0.0 as=0.0 pd=0.0 ps=0.0 ng=1
+ ws= w
+ ls= l
+ shk=1
+ dvthmat=(mv_modpm)*(1.5e-08/sqrt(ls*ws*ng)) dumat=(mu_modpm)*(7.1e-9/sqrt(ls*ws*ng))
//
if (modpm==1)
modpm ( d g s b ) mosinsub w=ws l=ls nrd=nrd nrs=nrs ad=ad as=as pd=pd ps=ps m=ng
else
modpm ( d s ) resistor r=1e30
notvalid paramtest errorif=(modpm==0) \
message="
***************************************************
*
* pmosm is not valid in selected process option.
*
***************************************************"
model mosinsub bsim3v3 version=3.2400e+00  type=p  capmod=2.0000e+00 \
 mobmod=1.0000e+00  nqsmod=0.0000e+00  noimod=3 \
   vbox=1.000e+03      k1=6.3108e-01 \
     k2=3.9998e-02      k3=8.3170e+00     k3b=-1.479e+00 \
    nch=9.4750e+16 vth0=-1.091e+00+dvthmat \
   voff=-1.148e-01    dvt0=5.3990e-01    dvt1=4.1120e-01 \
   dvt2=-9.479e-02    keta=3.0100e-02 \
 pscbe1=1.0000e+30  pscbe2=1.0000e-06 \
 alpha0=2.7100e-07  alpha1=1.9100e+00   beta0=3.4770e+01 \
  dvt0w=8.0990e-01   dvt1w=1.4800e+05   dvt2w=4.4040e-02 \
     ua=1.8000e-12      ub=2.2180e-18      uc=-7.278e-11 \
u0=1.2540e+02+(1.2540e+02)*dumat \
   dsub=5.0000e-01    eta0=9.7360e-02    etab=-2.948e-02 \
nfactor=7.0460e-01 \
     em=4.1000e+07    pclm=4.3950e+00 \
  drout=5.0000e-01 \
     a0=1.3860e+00      a1=0.0000e+00      a2=1.0000e+00 \
   pvag=0.0000e+00    vsat=1.4360e+05     ags=1.3640e-01      b0=1.9910e-08      b1=0.0000e+00 \
  delta=1.0000e-02 pdiblcb=1.0000e+00 \
pdiblc1=2.0370e-02 pdiblc2=1.0000e-20 \
     w0=1.0000e-10 \
    dlc=2.5000e-08 \
    dwc=6.2030e-08     dwb=0.0000e+00     dwg=0.0000e+00 \
     ll=0.000e+00      lw=0.000e+00     lwl=0.000e+00 \
    lln=1.000e+00     lwn=1.000e+00      wl=0.0000e+00 \
     ww=-9.750e-16     wwl=-1.787e-21     wln=1.0000e+00 \
     wr=1.0000e+00     wwn=1.0400e+00 \
     at=3.3000e+04     ute=-1.300e+00 \
    kt1=-6.003e-01     kt2=2.2000e-02    kt1l=0.0000e+00 \
    ua1=0.0000e+00     ub1=0.0000e+00     uc1=0.0000e+00 \
    prt=0.0000e+00 \
   cgso=9.1000e-11    cgdo=9.1000e-11    cgbo=1.1000e-10 \
   cgdl=6.5333e-11    cgsl=6.5333e-11  ckappa=6.0000e-01 \
     cf=0.0000e+00     elm=5.0000e+00 \
  xpart=1.0000e+00     clc=1.0000e-15     cle=6.0000e-01 \
   noff=1.0000e+00  voffcv=0.0000e+00 \
   rdsw=1.6230e+03 \
   cdsc=1.2140e-03   cdscb=2.9450e-04   cdscd=0.0000e+00 \
   prwb=-4.521e-01    prwg=0.0000e+00     cit=5.2590e-05 \
tox=1.5000e-08 \
  ngate=0.0000e+00 \
    nlx=2.2310e-07 \
     xl=9.0000e-08      xw=0.0000e+00 \
     af=1.5640e+00      kf=4.8520e-26      ef=1.0000e+00 \
   noia=1.8720e+18    noib=3.4540e+04    noic=1.2460e-12 \
     rd=0.0000e+00      rs=0.0000e+00     rsh=1.6120e+02 \
   minr=1.000e-03 \
    rdc=0.0000e+00     rsc=0.0000e+00 lint=-8.504e-08 \
wint=6.2030e-08   ldif=0.000e+00    hdif=6.0000e-07 \
     xj=3.0000e-07      js=2.8000e-07 \
      n=1.0000e+00 \
  dskip=no          tlev=0           tlevc=0         \
    jsw=3.7000e-13 \
     cj=1.5230e-03    cjsw=3.5840e-10 \
     fc=0.0000e+00    fcsw=0.000e+00 \
     mj=5.4000e-01    mjsw=4.6000e-01 \
     pb=1.0200e+00    pbsw=1.0200e+00     xti=1.9700e+00
ends modpm

// ----------------------------------------------------------------------

// ----------------------------------------------------------------------
// Owner: austriamicrosystems
// HIT-Kit: Digital
// ************************ SIMULATION PARAMETERS ************************
//  ----------------------------------------------------------------------
//  format    : Spectre (Spectre Direct)
//  model     : MOS BSIM3v3
//  process   : C35
//  revision  : 5.0;
//  extracted : B27167L1W5C45; 15-04-2007; bse (5866)
//  doc#      : Eng-182 REV_6
//  ----------------------------------------------------------------------
//                         WORST CASE ONE CONDITION
//
//  ----------------------------------------------------------------------
//
inline subckt modpml ( d g s b )
parameters w=1.0e-6 l=1.0e-6 nrd=0.0 nrs=0.0 ad=0.0 as=0.0 pd=0.0 ps=0.0 ng=1
+ ws= w
+ ls= l
+ shk=1
+ dvthmat=(mv_modpml)*(1.8e-08/sqrt(ls*ws*ng)) dumat=(mu_modpml)*(6.3e-9/sqrt(ls*ws*ng))
//
if (modpml==1)
modpml ( d g s b ) mosinsub w=ws l=ls nrd=6.0000e-07/ws nrs=6.0000e-07/ws ad=ad as=as pd=pd ps=ps m=ng
else
modpml ( d s ) resistor r=1e30
notvalid paramtest errorif=(modpml==0) \
message="
***************************************************
*
* pmosml is not valid in selected process option.
*
***************************************************"
model mosinsub bsim3v3 version=3.2400e+00  type=p  capmod=2.0000e+00 \
 mobmod=1.0000e+00  nqsmod=0.0000e+00  noimod=3.0000e+00 \
   vbox=1.000e+03      k1=6.7600e-01 \
     k2=-4.000e-03      k3=1.7420e+01     k3b=-1.738e+00 \
    nch=7.8980e+16 vth0=-7.880e-01+dvthmat \
   voff=-1.960e-01    dvt0=1.0000e+00    dvt1=4.2050e-01 \
   dvt2=-4.410e-02    keta=6.0000e-03 \
 pscbe1=1.0000e+30  pscbe2=1.0000e-06 \
 alpha0=1.3000e-07  alpha1=3.3320e-02   beta0=2.4820e+01 \
  dvt0w=5.7320e-01   dvt1w=2.8750e+05   dvt2w=1.6680e-01 \
     ua=3.3110e-09      ub=1.0000e-19      uc=-8.710e-11 \
u0=2.0610e+02+(2.0610e+02)*dumat \
   dsub=5.0000e-01    eta0=1.2500e-01    etab=-3.726e-04 \
nfactor=1.0210e+00 \
     em=4.1000e+07    pclm=2.5000e+00 \
  drout=5.0000e-01 \
     a0=1.1720e+00      a1=-1.581e-01      a2=1.0000e+00 \
   pvag=0.0000e+00    vsat=1.5690e+05     ags=1.4450e-01      b0=6.1800e-08      b1=0.0000e+00 \
  delta=2.9180e-02 pdiblcb=8.4520e-01 \
pdiblc1=1.1270e-02 pdiblc2=1.2500e-03 \
     w0=1.3800e-06 \
    dlc=4.5000e-08 \
    dwc=1.2300e-07     dwb=5.5110e-09     dwg=-5.171e-09 \
     ll=0.0000e+00      lw=0.0000e+00     lwl=0.0000e+00 \
    lln=1.0000e+00     lwn=1.0000e+00      wl=0.0000e+00 \
     ww=-4.460e-14     wwl=0.0000e+00     wln=1.0000e+00 \
     wr=1.0000e+00     wwn=1.0000e+00 \
     at=3.0000e+03     ute=-1.628e+00 \
    kt1=-6.603e-01     kt2=-8.840e-02    kt1l=0.0000e+00 \
    ua1=-2.399e-09     ub1=0.0000e+00     uc1=0.0000e+00 \
    prt=0.0000e+00 \
   cgso=6.4000e-11    cgdo=6.4000e-11    cgbo=1.1000e-10 \
   cgdl=1.7333e-10    cgsl=1.7333e-10  ckappa=1.4370e+00 \
     cf=0.0000e+00     elm=5.0000e+00 \
  xpart=1.0000e+00     clc=1.0000e-15     cle=6.0000e-01 \
\
   rdsw=6.3530e+02 \
   cdsc=1.4540e-04   cdscb=-2.792e-05   cdscd=0.0000e+00 \
   prwb=-3.097e-01    prwg=0.0000e+00     cit=0.0000e+00 \
tox=1.5000e-08 \
  ngate=1.0000e+00 \
    nlx=2.9510e-07 \
     xl=1.4990e-07      xw=-2.920e-09 \
     af=1.4710e+00      kf=1.3230e-26      ef=1.0000e+00 \
   noia=1.1970e+19    noib=2.6610e+04    noic=6.7840e-13 \
     rd=0.0000e+00      rs=0.0000e+00     rsh=1.6500e+02 \
   minr=1.000e-03 \
    rdc=0.0000e+00     rsc=0.0000e+00 lint=-7.553e-08 \
wint=1.2300e-07   ldif=0.000e+00    hdif=6.0000e-07 \
     xj=3.0000e-07      js=2.8000e-07 \
      n=1.0000e+00 \
  dskip=no          tlev=0           tlevc=0         \
    jsw=3.7000e-13 \
     cj=1.6320e-03    cjsw=4.2000e-10 \
     fc=0.0000e+00    fcsw=0.000e+00 \
     mj=5.4000e-01    mjsw=4.6000e-01 \
     pb=1.0200e+00    pbsw=1.0200e+00     xti=1.9700e+00
ends modpml

// ----------------------------------------------------------------------
//----------------------------------------------------------------------
//************************* SIMULATION PARAMETERS ************************
// ----------------------------------------------------------------------
// format    : Spectre ( Spectre Direct )
// model     : DIODE
// process   : C35
// revision  : 4.0;
// extracted : B10866 ; 2002-12; ese(5487)
// doc#      : ENG-182 REV_6
// ----------------------------------------------------------------------
//                        WORST CASE ONE CONDITION
// ----------------------------------------------------------------------
// TERMINALS: A=anode=P-region C=cathode=N-region
// VARIABLES: M (mulitiplier), AREA [m^2], PERI [m].
// NOTE: The role of a protection DIODE is to conduct ESD current to VDD
// (or from VSS). This forward bias is NOT modelled, only leakage current
// and capacitance during normal operation. Any inductive load etc that
// will give forward bias, must be limited by other components to within
// Operating Conditions, otherwise parasitic bipolar action can occur.
//
// Parameters: area perim
//
inline subckt nd ( a c )
parameters area=1.0e-12 perimeter=1.0e-6
//
if (subdiode==1)
nd ( a c ) diodeinsub area=area perim=perimeter region=off
else
nd ( a c ) resistor r=1e30
notvalid paramtest errorif=(subdiode==0) \
message="
***************************************************
*
* subdiode is not valid in selected process option.
*
***************************************************"
model diodeinsub diode level=1 dskip=no \
     is=5.1000e-07     isw=6.0000e-13       n=1.0000e+00      ns=1.0000e+00 \
   minr=0.100e+00    imax=(1.000e+00/area) \
    cjo=8.2700e-04       m=3.4000e-01      vj=6.9000e-01      tt=0.000e+00 \
    xti=2.0260e+00 \
   cjsw=2.2000e-10    mjsw=2.3000e-01    vjsw=6.9000e-01      fc=0.000e+00 \
     af=1.000e+00      kf=0.000e+00
ends nd
// ----------------------------------------------------------------------
// Owner: austriamicrosystems
// HIT-Kit: Digital
// ************************ SIMULATION PARAMETERS ************************
//  ----------------------------------------------------------------------
//  format    : Spectre (Spectre Direct)
//  model     : MOS BSIM3v3
//  process   : C35
//  revision  : 4.1;
//  extracted : C64685 ; 2002-12; ese(5487)
//  doc#      : ENG-182 REV_6
//  ----------------------------------------------------------------------
//                         WORST CASE ONE CONDITION
//
//  ----------------------------------------------------------------------
//
inline subckt modp ( d g s b )
parameters w=1.0e-6 l=1.0e-6 nrd=0.0 nrs=0.0 ad=0.0 as=0.0 pd=0.0 ps=0.0 ng=1
+ ws= w
+ ls= l
+ shk=1
+ dvthmat=(mv_modp)*(1.03e-08/sqrt(ls*ws*ng)) dumat=(mu_modp)*(7.1e-9/sqrt(ls*ws*ng))
//
if (modp==1)
modp ( d g s b ) mosinsub w=ws l=ls nrd=nrd nrs=nrs ad=ad as=as pd=pd ps=ps m=ng
else
modp ( d s ) resistor r=1e30
notvalid paramtest errorif=(modp==0) \
message="
***************************************************
*
* pmos is not valid in selected process option.
*
***************************************************"
model mosinsub bsim3v3 version=3.2400e+00  type=p  capmod=2.0000e+00 \
 mobmod=1.0000e+00  nqsmod=0.0000e+00  noimod=3 \
   vbox=1.000e+03      k1=5.9012e-01 \
     k2=-4.433e-02      k3=1.1030e+01     k3b=-7.580e-01 \
    nch=1.1460e+17 vth0=-7.715e-01+dvthmat \
   voff=-1.170e-01    dvt0=1.6500e+00    dvt1=3.8680e-01 \
   dvt2=1.6590e-02    keta=-1.440e-02 \
 pscbe1=1.0000e+30  pscbe2=1.0000e-06 \
 alpha0=1.0000e-09  alpha1=1.5000e+00   beta0=3.2500e+01 \
  dvt0w=1.8790e-01   dvt1w=7.3350e+04   dvt2w=-6.312e-03 \
     ua=5.3940e-10      ub=1.0530e-18      uc=1.0000e-20 \
u0=1.3140e+02+(1.3140e+02)*dumat \
   dsub=5.0000e-01    eta0=2.4800e-01    etab=-3.917e-03 \
nfactor=1.2140e+00 \
     em=4.1000e+07    pclm=3.1840e+00 \
  drout=5.0000e-01 \
     a0=5.8500e-01      a1=0.0000e+00      a2=1.0000e+00 \
   pvag=0.0000e+00    vsat=1.1580e+05     ags=2.4680e-01      b0=8.8320e-08      b1=0.0000e+00 \
  delta=1.0000e-02 pdiblcb=1.0000e+00 \
pdiblc1=1.0000e-04 pdiblc2=1.0000e-20 \
     w0=1.0000e-10 \
    dlc=2.4500e-08 \
    dwc=3.4490e-08     dwb=0.0000e+00     dwg=0.0000e+00 \
     ll=0.000e+00      lw=0.000e+00     lwl=0.000e+00 \
    lln=1.000e+00     lwn=1.000e+00      wl=0.0000e+00 \
     ww=1.8940e-16     wwl=-1.981e-21     wln=1.0000e+00 \
     wr=1.0000e+00     wwn=1.0400e+00 \
     at=3.3000e+04     ute=-1.300e+00 \
    kt1=-5.403e-01     kt2=2.2000e-02    kt1l=0.0000e+00 \
    ua1=0.0000e+00     ub1=0.0000e+00     uc1=0.0000e+00 \
    prt=0.0000e+00 \
   cgso=8.6000e-11    cgdo=8.6000e-11    cgbo=1.1000e-10 \
   cgdl=1.1667e-10    cgsl=1.1667e-10  ckappa=6.0000e-01 \
     cf=0.0000e+00     elm=5.0000e+00 \
  xpart=1.0000e+00     clc=1.0000e-15     cle=6.0000e-01 \
   noff=1.0000e+00  voffcv=0.0000e+00 \
   rdsw=1.0330e+03 \
   cdsc=2.5890e-03   cdscb=2.9430e-04   cdscd=4.3700e-04 \
   prwb=-9.731e-02    prwg=1.4770e-01     cit=0.0000e+00 \
tox=7.6000e-09 \
  ngate=0.0000e+00 \
    nlx=1.7700e-07 \
     xl=4.0000e-08      xw=5.0000e-09 \
     af=1.4050e+00      kf=1.8270e-26      ef=1.0000e+00 \
   noia=7.0910e+18    noib=6.0740e+04    noic=3.7790e-13 \
     rd=0.0000e+00      rs=0.0000e+00     rsh=1.6000e+02 \
   minr=1.000e-03 \
    rdc=0.0000e+00     rsc=0.0000e+00 lint=-7.130e-08 \
wint=3.4490e-08   ldif=0.000e+00    hdif=8.0000e-07 \
     xj=3.0000e-07      js=2.8000e-07 \
      n=1.0000e+00 \
  dskip=no          tlev=0           tlevc=0         \
    jsw=3.7000e-13 \
     cj=1.5230e-03    cjsw=3.5800e-10 \
     fc=0.0000e+00    fcsw=0.000e+00 \
     mj=5.4000e-01    mjsw=4.6000e-01 \
     pb=1.0200e+00    pbsw=1.0200e+00     xti=1.9730e+00
ends modp

// ----------------------------------------------------------------------

// ----------------------------------------------------------------------
// Owner: austriamicrosystems
// HIT-Kit: Digital
// ************************ SIMULATION PARAMETERS ************************
//  ----------------------------------------------------------------------
//  format    : Spectre (Spectre Direct)
//  model     : MOS BSIM3v3
//  process   : C35
//  revision  : 5.0;
//  extracted : B27167L1W5C45; 15-04-2007; bse (5866)
//  doc#      : Eng-182 REV_6
//  ----------------------------------------------------------------------
//                         WORST CASE ONE CONDITION
//
//  ----------------------------------------------------------------------
//
inline subckt modpl ( d g s b )
parameters w=1.0e-6 l=1.0e-6 nrd=0.0 nrs=0.0 ad=0.0 as=0.0 pd=0.0 ps=0.0 ng=1
+ ws= w
+ ls= l
+ shk=1
+ dvthmat=(mv_modpl)*(1.24e-08/sqrt(ls*ws*ng)) dumat=(mu_modpl)*(5.7e-9/sqrt(ls*ws*ng))
//
if (modpl==1)
modpl ( d g s b ) mosinsub w=ws l=ls nrd=8.0000e-07/ws nrs=8.0000e-07/ws ad=ad as=as pd=pd ps=ps m=ng
else
modpl ( d s ) resistor r=1e30
notvalid paramtest errorif=(modpl==0) \
message="
***************************************************
*
* pmosl is not valid in selected process option.
*
***************************************************"
model mosinsub bsim3v3 version=3.2400e+00  type=p  capmod=2.0000e+00 \
 mobmod=1.0000e+00  nqsmod=0.0000e+00  noimod=3.0000e+00 \
   vbox=1.000e+03      k1=6.8800e-01 \
     k2=-7.790e-02      k3=5.2610e+01     k3b=7.2440e+00 \
    nch=9.4750e+16 vth0=-6.040e-01+dvthmat \
   voff=-2.280e-01    dvt0=1.0460e+00    dvt1=3.9190e-01 \
   dvt2=1.9100e-03    keta=-2.400e-03 \
 pscbe1=1.0000e+30  pscbe2=1.0000e-06 \
 alpha0=1.1750e-08  alpha1=1.0000e-03   beta0=1.9580e+01 \
  dvt0w=1.0000e+00   dvt1w=5.3000e+06   dvt2w=9.5620e-02 \
     ua=1.0000e-12      ub=1.9050e-18      uc=6.3100e-11 \
u0=1.2950e+02+(1.2950e+02)*dumat \
   dsub=5.0000e-01    eta0=1.9590e-01    etab=0.0000e+00 \
nfactor=1.5790e+00 \
     em=4.1000e+07    pclm=8.2410e-01 \
  drout=5.0000e-01 \
     a0=5.0000e-01      a1=0.0000e+00      a2=1.0000e+00 \
   pvag=0.0000e+00    vsat=9.8190e+04     ags=2.6300e-01      b0=6.0600e-08      b1=0.0000e+00 \
  delta=4.3330e-03 pdiblcb=9.6330e-01 \
pdiblc1=1.0000e-03 pdiblc2=1.3800e-03 \
     w0=1.9050e-06 \
    dlc=2.0000e-08 \
    dwc=7.2920e-08     dwb=1.6220e-08     dwg=0.0000e+00 \
     ll=0.0000e+00      lw=0.0000e+00     lwl=0.0000e+00 \
    lln=1.0000e+00     lwn=1.0000e+00      wl=0.0000e+00 \
     ww=-2.000e-14     wwl=0.0000e+00     wln=1.0000e+00 \
     wr=1.0000e+00     wwn=1.0400e+00 \
     at=3.3000e+04     ute=-1.280e+00 \
    kt1=-5.577e-01     kt2=-6.560e-02    kt1l=0.0000e+00 \
    ua1=0.0000e+00     ub1=0.0000e+00     uc1=0.0000e+00 \
    prt=0.0000e+00 \
   cgso=5.6000e-11    cgdo=5.6000e-11    cgbo=1.1000e-10 \
   cgdl=2.6000e-10    cgsl=2.6000e-10  ckappa=5.6400e-01 \
     cf=0.0000e+00     elm=5.0000e+00 \
  xpart=1.0000e+00     clc=1.0000e-15     cle=6.0000e-01 \
\
   rdsw=2.0890e+03 \
   cdsc=1.3750e-03   cdscb=4.4880e-04   cdscd=1.9130e-04 \
   prwb=3.8020e-02    prwg=-1.047e-01     cit=0.0000e+00 \
tox=7.6000e-09 \
  ngate=1.0000e+00 \
    nlx=1.6220e-07 \
     xl=1.0000e-07      xw=1.0030e-09 \
     af=1.4690e+00      kf=1.2960e-26      ef=1.0000e+00 \
   noia=2.9220e+19    noib=1.7730e+04    noic=4.5200e-13 \
     rd=0.0000e+00      rs=0.0000e+00     rsh=1.6500e+02 \
   minr=1.000e-03 \
    rdc=0.0000e+00     rsc=0.0000e+00 lint=-1.285e-08 \
wint=7.2920e-08   ldif=0.000e+00    hdif=8.0000e-07 \
     xj=3.0000e-07      js=2.8000e-07 \
      n=1.0000e+00 \
  dskip=no          tlev=0           tlevc=0         \
    jsw=3.7000e-13 \
     cj=1.6320e-03    cjsw=4.2000e-10 \
     fc=0.0000e+00    fcsw=0.000e+00 \
     mj=5.4000e-01    mjsw=4.6000e-01 \
     pb=1.0200e+00    pbsw=1.0200e+00     xti=1.9700e+00
ends modpl

// ----------------------------------------------------------------------
//----------------------------------------------------------------------
//************************* SIMULATION PARAMETERS ************************
// ----------------------------------------------------------------------
// format    : Spectre ( Spectre Direct )
// model     : DIODE
// process   : C35
// revision  : 4.1;
// extracted : C64685 ; 2002-12; ese(5487)
// doc#      : ENG-182 REV_6
// ----------------------------------------------------------------------
//                        WORST CASE ONE CONDITION
// ----------------------------------------------------------------------
// TERMINALS: A=anode=P-region C=cathode=N-region
// VARIABLES: M (mulitiplier), AREA [m^2], PERI [m].
// NOTE: The role of a protection DIODE is to conduct ESD current to VDD
// (or from VSS). This forward bias is NOT modelled, only leakage current
// and capacitance during normal operation. Any inductive load etc that
// will give forward bias, must be limited by other components to within
// Operating Conditions, otherwise parasitic bipolar action can occur.
//
// Parameters: area perim
//
inline subckt pd ( a c )
parameters area=1.0e-12 perimeter=1.0e-6
//
if (welldiode==1)
pd ( a c ) diodeinsub area=area perim=perimeter region=off
else
pd ( a c ) resistor r=1e30
notvalid paramtest errorif=(welldiode==0) \
message="
***************************************************
*
* welldiode is not valid in selected process option.
*
***************************************************"
model diodeinsub diode level=1 dskip=no \
     is=2.8000e-07     isw=3.7000e-13       n=1.0000e+00      ns=1.0000e+00 \
   minr=0.100e+00    imax=(1.000e+00/area) \
    cjo=1.5230e-03       m=5.4000e-01      vj=1.0200e+00      tt=0.000e+00 \
    xti=1.9730e+00 \
   cjsw=3.5800e-10    mjsw=4.6000e-01    vjsw=1.0200e+00      fc=0.000e+00 \
     af=1.000e+00      kf=0.000e+00
ends pd
// ----------------------------------------------------------------------
// Owner: austriamicrosystems
// HIT-Kit: Digital
// ************************ SIMULATION PARAMETERS ************************
//  ----------------------------------------------------------------------
//  format    : Spectre (Spectre Direct)
//  model     : MOS BSIM3v3
//  process   : C35
//  revision  : 4.1;
//  extracted : C35 B11004.L2; 2002-11; hhl(5481)
//  doc#      : Eng-182  REV_6.0
//  ----------------------------------------------------------------------
//                        WORST CASE ONE CONDITION
//  ----------------------------------------------------------------------
//  HV-TRANSISTOR
//  ----------------------------------------------------------------------
inline subckt modnmh ( d g s b )
// Parameters: w l nrd nrs ad as pd ps
parameters w=1.0e-6 l=1.0e-6 nrd=0.0 nrs=0.0 ad=0.0 as=0.0 pd=0.0 ps=0.0 mult=1
+ ws=w
+ ls=l
+ dvthmat=mv_modnmh*(1.03e-08/sqrt(ls*ws*mult)) dumat=mu_modnmh*(3.5e-9/sqrt(ls*ws*mult))
//
if (modnmh==1){
modnmh ( d1 g s b ) mosinsub w=ws l=ls nrd=0 nrs=6.0000e-07/ws ad=ad as=as pd=pd ps=ps
rd ( d1 d ) resistor r=(1.1600e+03*4.0000e-06/(ws)) tc1=6.2000e-03
}else
modnmh ( d s ) resistor r=1e30
notvalid paramtest errorif=(modnmh==0) \
message="
***************************************************
*
* nmosmh is not valid in selected process option.
*
***************************************************"
//
model mosinsub bsim3v3 version=3.1 type=n  capmod=2.0000e+00 \
 mobmod=1.0000e+00  nqsmod=0.0000e+00  noimod=3 \
   vbox=1.000e+03      k1=7.6812e-01 \
     k2=7.1587e-02      k3=-2.439e+00     k3b=4.0770e-01 \
    nch=1.7730e+17 vth0=5.1490e-01+dvthmat \
   voff=-4.948e-02    dvt0=4.9850e+01    dvt1=1.6830e+00 \
   dvt2=4.1260e-02    keta=-7.397e-02 \
 pscbe1=4.0000e+10  pscbe2=1.0000e-10 \
 alpha0=0.0000e+00   beta0=3.0000e+01 \
  dvt0w=0.0000e+00   dvt1w=0.0000e+00   dvt2w=0.0000e+00 \
     ua=1.0000e-12      ub=3.7680e-19      uc=6.3910e-12 \
u0=4.9230e+02+(4.9230e+02)*dumat \
   dsub=5.0000e-01    eta0=1.6160e-03    etab=-1.373e-02 \
nfactor=3.4550e-01 \
     em=4.1000e+07    pclm=1.0550e-01 \
  drout=5.0000e-01 \
     a0=2.1900e-01      a1=0.0000e+00      a2=1.0000e+00 \
   pvag=0.0000e+00    vsat=5.1290e+04     ags=9.4480e-02      b0=-3.629e-08      b1=0.0000e+00 \
  delta=3.3700e-03 pdiblcb=3.8720e-01 \
pdiblc1=1.0000e-10 pdiblc2=1.0000e-10 \
     w0=6.2890e-08 \
    dlc=8.9170e-08 \
    dwc=4.9380e-08     dwb=0.0000e+00     dwg=0.0000e+00 \
     ll=0.0000e+00      lw=0.0000e+00     lwl=0.0000e+00 \
    lln=1.0000e+00     lwn=1.0000e+00      wl=0.0000e+00 \
     ww=0.0000e+00     wwl=0.0000e+00     wln=1.0000e+00 \
    wwn=1.0000e+00 \
   tnom=2.7000e+01      at=3.3000e+04     ute=-1.760e+00 \
    kt1=-4.502e-01     kt2=2.2000e-02    kt1l=0.0000e+00 \
    ua1=0.0000e+00     ub1=0.0000e+00     uc1=0.0000e+00 \
    prt=0.0000e+00 \
   cgso=9.9333e-11    cgdo=9.9333e-11    cgbo=1.1000e-10 \
   cgdl=0.0000e+00    cgsl=0.0000e+00  ckappa=6.0000e-01 \
     cf=0.0000e+00     elm=5.0000e+00 \
  xpart=1.0000e+00     clc=1.0000e-15     cle=6.0000e-01 \
\
   rdsw=5.3040e+02 \
   cdsc=1.0000e-02   cdscb=0.0000e+00   cdscd=8.4480e-05 \
   prwb=0.0000e+00    prwg=0.0000e+00     cit=8.1220e-04 \
tox=1.5000e-08 \
  ngate=0.0000e+00 \
    nlx=1.5930e-07 \
     xl=-1.050e-06      xw=-5.000e-08 \
     af=1.3580e+00      kf=3.4460e-26      ef=1.0000e+00 \
   noia=1.7020e+20    noib=5.4630e+05    noic=-1.400e-11 \
     rd=0.0000e+00      rs=0.0000e+00     rsh=5.5000e+01 \
   minr=1.000e-03 \
    rdc=0.0000e+00     rsc=0.0000e+00 lint=8.9170e-08 \
wint=4.9380e-08   ldif=0.000e+00    hdif=6.0000e-07 \
     xj=3.0000e-07      js=5.1000e-07 \
      n=1.0000e+00 \
  dskip=no          tlev=0           tlevc=0         \
    jsw=6.0000e-13 \
     cj=6.0000e-05    cjsw=3.8250e-10 \
     fc=0.0000e+00    fcsw=0.000e+00 \
     mj=3.9000e-01    mjsw=2.7000e-01 \
     pb=5.3000e-01    pbsw=6.9000e-01     xti=2.0260e+00
ends modnmh
// ----------------------------------------------------------------------
// Owner: austriamicrosystems
// HIT-Kit: Digital
// ************************ SIMULATION PARAMETERS ************************
//  ----------------------------------------------------------------------
//  format    : Spectre (Spectre Direct)
//  model     : MOS BSIM3v3
//  process   : c35
//  revision  : 4.1;
//  extracted : Wafer B26654W01 2005/10/10 REVISION 4.0; wpc(5481)
//  doc#      : Eng-182  REV 6.0
//  ----------------------------------------------------------------------
//                        WORST CASE ONE CONDITION
//  ----------------------------------------------------------------------
//  HV-TRANSISTOR
//  ----------------------------------------------------------------------
inline subckt modnmhl ( d g s b )
// Parameters: w l nrd nrs ad as pd ps
parameters w=1.0e-6 l=1.0e-6 nrd=0.0 nrs=0.0 ad=0.0 as=0.0 pd=0.0 ps=0.0 mult=1
+ ws=w
+ ls=l
+ dvthmat=mv_modnmhl*(0.95e-08/sqrt(ls*ws*mult)) dumat=mu_modnmhl*(3.5e-9/sqrt(ls*ws*mult))
//
if (modnmhl==1){
modnmhl ( d1 g s b ) mosinsub w=ws l=ls nrd=0 nrs=8.0000e-07/ws ad=ad as=as pd=pd ps=ps
rd ( d1 d ) resistor r=(1.0810e+03*4.0000e-06/(ws+(0.0000e+00))) tc1=6.2000e-03
}else
modnmhl ( d s ) resistor r=1e30
notvalid paramtest errorif=(modnmhl==0) \
message="
***************************************************
*
* nmosmhl is not valid in selected process option.
*
***************************************************"
//
model mosinsub bsim3v3 version=3.1 type=n  capmod=2.0000e+00 \
 mobmod=1.0000e+00  nqsmod=0.0000e+00  noimod=3 \
   vbox=1.000e+03      k1=7.3575e-01 \
     k2=3.8932e-02      k3=0.0000e+00     k3b=0.0000e+00 \
    nch=1.1720e+17 vth0=3.9500e-01+dvthmat \
   voff=-5.565e-02    dvt0=0.0000e+00    dvt1=1.6830e+00 \
   dvt2=4.1260e-02    keta=-8.210e-02 \
 pscbe1=4.0000e+10  pscbe2=1.0000e-10 \
 alpha0=0.0000e+00   beta0=3.0000e+01 \
  dvt0w=0.0000e+00   dvt1w=0.0000e+00   dvt2w=0.0000e+00 \
     ua=2.2380e-10      ub=0.0000e+00      uc=-1.429e-11 \
u0=5.7430e+02+(5.7430e+02)*dumat \
   dsub=5.0000e-01    eta0=1.6160e-03    etab=-1.373e-02 \
nfactor=8.5500e-01 \
     em=4.1000e+07    pclm=1.0550e-01 \
  drout=5.0000e-01 \
     a0=4.7540e-02      a1=0.0000e+00      a2=1.0000e+00 \
   pvag=0.0000e+00    vsat=5.2060e+04     ags=-3.227e-01      b0=0.0000e+00      b1=0.0000e+00 \
  delta=1.5850e-02 pdiblcb=3.8720e-01 \
pdiblc1=1.0000e-10 pdiblc2=1.0000e-10 \
     w0=0.0000e+00 \
    dlc=0.0000e+00 \
    dwc=0.0000e+00     dwb=0.0000e+00     dwg=0.0000e+00 \
     ll=0.0000e+00      lw=0.0000e+00     lwl=0.0000e+00 \
    lln=1.0000e+00     lwn=1.0000e+00      wl=0.0000e+00 \
     ww=0.0000e+00     wwl=0.0000e+00     wln=1.0000e+00 \
    wwn=1.0000e+00 \
     at=3.3000e+04     ute=-1.720e+00 \
    kt1=-4.202e-01     kt2=2.2000e-02    kt1l=0.0000e+00 \
    ua1=0.0000e+00     ub1=0.0000e+00     uc1=0.0000e+00 \
    prt=0.0000e+00 \
   cgso=8.6667e-11    cgdo=8.6667e-11    cgbo=1.1000e-10 \
   cgdl=0.0000e+00    cgsl=0.0000e+00  ckappa=6.0000e-01 \
     cf=0.0000e+00     elm=5.0000e+00 \
  xpart=1.0000e+00     clc=1.0000e-15     cle=6.0000e-01 \
\
   rdsw=5.3040e+02 \
   cdsc=0.0000e+00   cdscb=0.0000e+00   cdscd=0.0000e+00 \
   prwb=0.0000e+00    prwg=0.0000e+00     cit=2.9310e-05 \
tox=1.5400e-08 \
  ngate=0.0000e+00 \
    nlx=1.5930e-07 \
     xl=-1.000e-07      xw=0.0000e+00 \
     af=1.4000e+00      kf=3.7700e-26      ef=1.0000e+00 \
   noia=1.5360e+20    noib=3.5840e+05    noic=-1.304e-11 \
     rd=0.0000e+00      rs=0.0000e+00     rsh=7.5000e+01 \
   minr=1.000e-03 \
    rdc=0.0000e+00     rsc=0.0000e+00 lint=6.0000e-07 \
wint=0.0000e+00   ldif=0.000e+00    hdif=8.0000e-07 \
     xj=3.0000e-07      js=5.1000e-07 \
      n=1.0000e+00 \
  dskip=no          tlev=0           tlevc=0         \
    jsw=6.0000e-13 \
     cj=6.2250e-04    cjsw=1.8750e-10 \
     fc=0.0000e+00    fcsw=0.000e+00 \
     mj=3.4000e-01    mjsw=2.3000e-01 \
     pb=6.9000e-01    pbsw=6.9000e-01     xti=2.0300e+00
ends modnmhl
// ----------------------------------------------------------------------
// Owner: austriamicrosystems
// HIT-Kit: Digital
// ************************ SIMULATION PARAMETERS ************************
//  ----------------------------------------------------------------------
//  format    : Spectre (Spectre Direct)
//  model     : MOS BSIM3v3
//  process   : C35
//  revision  : 4.1;
//  extracted : C35 B11004.L2; 2002-11; hhl(5481)
//  doc#      : Eng-182  REV_6.0
//  ----------------------------------------------------------------------
//                        WORST CASE ONE CONDITION
//  ----------------------------------------------------------------------
//  HV-TRANSISTOR
//  ----------------------------------------------------------------------
inline subckt modnh ( d g s b )
// Parameters: w l nrd nrs ad as pd ps
parameters w=1.0e-6 l=1.0e-6 nrd=0.0 nrs=0.0 ad=0.0 as=0.0 pd=0.0 ps=0.0 mult=1
+ ws=w
+ ls=l
+ dvthmat=mv_modnh*(0.67e-08/sqrt(ls*ws*mult)) dumat=mu_modnh*(4.9e-9/sqrt(ls*ws*mult))
//
if (modnh==1){
modnh ( d1 g s b ) mosinsub w=ws l=ls nrd=0 nrs=6.0000e-07/ws ad=ad as=as pd=pd ps=ps
rd ( d1 d ) resistor r=(9.9600e+02*4.0000e-06/(ws)) tc1=6.2000e-03
}else
modnh ( d s ) resistor r=1e30
notvalid paramtest errorif=(modnh==0) \
message="
***************************************************
*
* nmosh is not valid in selected process option.
*
***************************************************"
//
model mosinsub bsim3v3 version=3.1 type=n  capmod=2.0000e+00 \
 mobmod=1.0000e+00  nqsmod=0.0000e+00  noimod=3 \
   vbox=1.000e+03      k1=5.6009e-01 \
     k2=-7.327e-03      k3=-2.240e+00     k3b=6.9540e-01 \
    nch=1.7590e+17 vth0=3.3600e-01+dvthmat \
   voff=-5.090e-02    dvt0=4.9850e+01    dvt1=1.2960e+00 \
   dvt2=1.3110e-02    keta=-4.553e-02 \
 pscbe1=1.0000e+10  pscbe2=1.0240e-05 \
 alpha0=0.0000e+00   beta0=3.0000e+01 \
  dvt0w=0.0000e+00   dvt1w=0.0000e+00   dvt2w=0.0000e+00 \
     ua=1.0000e-30      ub=1.9490e-18      uc=1.2170e-10 \
u0=3.7570e+02+(3.7570e+02)*dumat \
   dsub=5.0000e-01    eta0=3.0750e-02    etab=-5.261e-02 \
nfactor=2.0340e-01 \
     em=4.1000e+07    pclm=2.9400e-01 \
  drout=5.0000e-01 \
     a0=1.8930e-01      a1=0.0000e+00      a2=1.0000e+00 \
   pvag=0.0000e+00    vsat=2.4020e+05     ags=1.2450e-01      b0=6.7900e-08      b1=0.0000e+00 \
  delta=1.7290e-02 pdiblcb=2.0670e-01 \
pdiblc1=3.0900e-02 pdiblc2=6.3750e-04 \
     w0=1.1450e-07 \
    dlc=6.0000e-07 \
    dwc=2.6050e-08     dwb=0.0000e+00     dwg=0.0000e+00 \
     ll=0.0000e+00      lw=0.0000e+00     lwl=0.0000e+00 \
    lln=1.0000e+00     lwn=1.0000e+00      wl=0.0000e+00 \
     ww=0.0000e+00     wwl=0.0000e+00     wln=1.0000e+00 \
    wwn=1.0000e+00 \
   tnom=2.7000e+01      at=3.3000e+04     ute=-1.800e+00 \
    kt1=-3.302e-01     kt2=2.2000e-02    kt1l=0.0000e+00 \
    ua1=0.0000e+00     ub1=0.0000e+00     uc1=0.0000e+00 \
    prt=0.0000e+00 \
   cgso=1.1000e-10    cgdo=1.1000e-10    cgbo=1.1000e-10 \
   cgdl=0.0000e+00    cgsl=0.0000e+00  ckappa=6.0000e-01 \
     cf=0.0000e+00     elm=5.0000e+00 \
  xpart=1.0000e+00     clc=1.0000e-15     cle=6.0000e-01 \
\
   rdsw=1.0920e+03 \
   cdsc=7.9440e-03   cdscb=0.0000e+00   cdscd=8.4480e-05 \
   prwb=0.0000e+00    prwg=0.0000e+00     cit=1.0000e-03 \
tox=7.6000e-09 \
  ngate=0.0000e+00 \
    nlx=1.1320e-07 \
     xl=0.0000e+00      xw=-5.000e-08 \
     af=1.3580e+00      kf=3.4460e-26      ef=1.0000e+00 \
   noia=1.7020e+20    noib=5.4630e+05    noic=-1.400e-11 \
     rd=0.0000e+00      rs=0.0000e+00     rsh=5.5000e+01 \
   minr=1.000e-03 \
    rdc=0.0000e+00     rsc=0.0000e+00 lint=6.0000e-07 \
wint=2.6050e-08   ldif=0.000e+00    hdif=6.0000e-07 \
     xj=3.0000e-07      js=5.1000e-07 \
      n=1.0000e+00 \
  dskip=no          tlev=0           tlevc=0         \
    jsw=6.0000e-13 \
     cj=6.0000e-05    cjsw=3.8250e-10 \
     fc=0.0000e+00    fcsw=0.000e+00 \
     mj=3.9000e-01    mjsw=2.7000e-01 \
     pb=5.3000e-01    pbsw=6.9000e-01     xti=2.0260e+00
ends modnh
// ----------------------------------------------------------------------
// Owner: austriamicrosystems
// HIT-Kit: Digital
// ************************ SIMULATION PARAMETERS ************************
//  ----------------------------------------------------------------------
//  format    : Spectre (Spectre Direct)
//  model     : MOS BSIM3v3
//  process   : c35
//  revision  : 4.0;
//  extracted : Wafer B26654W01 2005/10/05 REVISION 4.0; wpc(5481)
//  doc#      : Eng-182  REV 6.0
//  ----------------------------------------------------------------------
//                        WORST CASE ONE CONDITION
//  ----------------------------------------------------------------------
//  HV-TRANSISTOR
//  ----------------------------------------------------------------------
inline subckt modnhl ( d g s b )
// Parameters: w l nrd nrs ad as pd ps
parameters w=1.0e-6 l=1.0e-6 nrd=0.0 nrs=0.0 ad=0.0 as=0.0 pd=0.0 ps=0.0 mult=1
+ ws=w
+ ls=l
+ dvthmat=mv_modnhl*(0.67e-08/sqrt(ls*ws*mult)) dumat=mu_modnhl*(4.9e-9/sqrt(ls*ws*mult))
//
if (modnhl==1){
modnhl ( d1 g s b ) mosinsub w=ws l=ls nrd=0 nrs=8.0000e-07/ws ad=ad as=as pd=pd ps=ps
rd ( d1 d ) resistor r=(4.5000e+02*4.0000e-06/(ws+(0.0000e+00))) tc1=6.2000e-03
}else
modnhl ( d s ) resistor r=1e30
notvalid paramtest errorif=(modnhl==0) \
message="
***************************************************
*
* nmoshl is not valid in selected process option.
*
***************************************************"
//
model mosinsub bsim3v3 version=3.1 type=n  capmod=2.0000e+00 \
 mobmod=1.0000e+00  nqsmod=0.0000e+00  noimod=3 \
   vbox=1.000e+03      k1=4.4663e-01 \
     k2=-2.880e-03      k3=0.0000e+00     k3b=0.0000e+00 \
    nch=1.1860e+17 vth0=2.6560e-01+dvthmat \
   voff=-5.119e-02    dvt0=0.0000e+00    dvt1=1.2960e+00 \
   dvt2=1.3110e-02    keta=-3.955e-02 \
 pscbe1=1.0000e+10  pscbe2=1.0240e-05 \
 alpha0=0.0000e+00   beta0=3.0000e+01 \
  dvt0w=0.0000e+00   dvt1w=0.0000e+00   dvt2w=0.0000e+00 \
     ua=1.0000e-30      ub=1.9490e-18      uc=1.2170e-10 \
u0=3.4910e+02+(3.4910e+02)*dumat \
   dsub=5.0000e-01    eta0=0.0000e+00    etab=0.0000e+00 \
nfactor=1.1530e+00 \
     em=4.1000e+07    pclm=2.9400e-01 \
  drout=5.0000e-01 \
     a0=3.3100e-01      a1=0.0000e+00      a2=1.0000e+00 \
   pvag=0.0000e+00    vsat=2.4020e+06     ags=3.2310e-01      b0=0.0000e+00      b1=0.0000e+00 \
  delta=3.1850e-02 pdiblcb=2.0670e-04 \
pdiblc1=3.0900e-02 pdiblc2=6.3750e-04 \
     w0=1.1450e-07 \
    dlc=0.0000e+00 \
    dwc=0.0000e+00     dwb=0.0000e+00     dwg=0.0000e+00 \
     ll=0.0000e+00      lw=0.0000e+00     lwl=0.0000e+00 \
    lln=1.0000e+00     lwn=1.0000e+00      wl=0.0000e+00 \
     ww=0.0000e+00     wwl=0.0000e+00     wln=1.0000e+00 \
    wwn=1.0000e+00 \
     at=3.3000e+04     ute=-1.700e+00 \
    kt1=-3.001e-01     kt2=2.2000e-02    kt1l=0.0000e+00 \
    ua1=0.0000e+00     ub1=0.0000e+00     uc1=0.0000e+00 \
    prt=0.0000e+00 \
   cgso=1.1000e-10    cgdo=1.1000e-10    cgbo=1.1000e-10 \
   cgdl=0.0000e+00    cgsl=0.0000e+00  ckappa=6.0000e-01 \
     cf=0.0000e+00     elm=5.0000e+00 \
  xpart=1.0000e+00     clc=1.0000e-15     cle=6.0000e-01 \
\
   rdsw=1.0920e+03 \
   cdsc=0.0000e+00   cdscb=0.0000e+00   cdscd=0.0000e+00 \
   prwb=0.0000e+00    prwg=0.0000e+00     cit=-2.050e-04 \
tox=7.6000e-09 \
  ngate=0.0000e+00 \
    nlx=1.1320e-07 \
     xl=-9.000e-08      xw=0.0000e+00 \
     af=1.4000e+00      kf=3.7700e-26      ef=1.0000e+00 \
   noia=1.5360e+20    noib=3.5840e+05    noic=-1.304e-11 \
     rd=0.0000e+00      rs=0.0000e+00     rsh=7.5000e+01 \
   minr=1.000e-03 \
    rdc=0.0000e+00     rsc=0.0000e+00 lint=6.0000e-07 \
wint=0.0000e+00   ldif=0.000e+00    hdif=8.0000e-07 \
     xj=3.0000e-07      js=5.1000e-07 \
      n=1.0000e+00 \
  dskip=no          tlev=0           tlevc=0         \
    jsw=6.0000e-13 \
     cj=6.2250e-04    cjsw=1.8750e-10 \
     fc=0.0000e+00    fcsw=0.000e+00 \
     mj=3.4000e-01    mjsw=2.3000e-01 \
     pb=6.9000e-01    pbsw=6.9000e-01     xti=2.0300e+00
ends modnhl
// ----------------------------------------------------------------------
// Owner: austriamicrosystems
// HIT-Kit: Digital
// ************************ SIMULATION PARAMETERS ************************
//  ----------------------------------------------------------------------
//  format    : Spectre (Spectre Direct)
//  model     : MOS BSIM3v3
//  process   : c35
//  revision  : ;
//  extracted : B58737.W09PE6; 2008-06; kmo(5966)
//  doc#      : ENG-327 Rev.2.0
//  ----------------------------------------------------------------------
//                        WORST CASE ONE CONDITION
//  ----------------------------------------------------------------------
//  HV-TRANSISTOR
//  ----------------------------------------------------------------------
inline subckt modn30m ( d g s b )
// Parameters: w l nrd nrs ad as pd ps
parameters w=1.0e-6 l=1.0e-6 nrd=0.0 nrs=0.0 ad=0.0 as=0.0 pd=0.0 ps=0.0 mult=1 gv=(7.6860e-08/l + 9.1600e-01) dcdc=1
+ dvthmat=mv_modn30m*(0.56e-08/sqrt(l*w*mult)) dumat=mu_modn30m*(2.9e-9/sqrt(l*w*mult))
if (modn30m==1){
//
modn30m ( d1 g s1 b ) mosinsub w=w l=l nrd=0 nrs=8.0000e-07/w ad=0 as=as pd=0 ps=ps
rd ( d1 d ) resistor r=(9.9260e-01/(w+(1.6670e-06))) tc1=6.0000e-03
xj1 ( d gj d1 ) modn30mjfet1 w=w
xj2 ( d gj d1 ) modn30mjfet2 w=w
e1 ( d1 gj d1 s ) vcvs gain=gv min=-25 max=25
cgdx ( g d ) capacitor c=(3.0983e-10*w)
v1 ( s1 s ) vsource dc=0 type=dc
i1 ( d b ) bsource i=((6.1450e-10)/(l+(0.0000e+00))+(6.1590e-03))*i("v1:p")*(max((v(d,g)+(1.8290e-02)),1e-15))**(4.1480e+00)*exp((-1.4550e+01)/max((v(d,g)+(1.8290e-02)),1e-10))*(w+0.0000e+00)/w/(1+2.8000e+04*exp(7.7390e-03*i("v1:p")/(w+0.0000e+00)))
xdw ( b d1 ) modn30mnwd area=(1e-06*2.35*(w+1e-06*16)) perimeter=(4e-06*2.35+(w+1e-06*16))
}else
modn30m ( d s ) resistor r=1e30
notvalid paramtest errorif=(modn30m==0) \
message="
***************************************************
*
* nmos30m is not valid in selected process option.
*
***************************************************"
//
model mosinsub bsim3v3 version=3.1 type=n  capmod=2.0000e+00 \
 mobmod=1.0000e+00  nqsmod=0.0000e+00  noimod=3.0000e+00 \
   vbox=1.000e+03      k1=8.5082e-01 \
     k2=4.6047e-02      k3=2.3030e-01     k3b=-1.516e-02 \
    nch=1.7070e+17 vth0=6.0770e-01+dvthmat \
   voff=-6.529e-02    dvt0=1.1390e-03    dvt1=1.0310e-01 \
   dvt2=-1.601e-01    keta=-1.236e-02 \
 pscbe1=3.5770e+12  pscbe2=5.7730e-12 \
 alpha0=0.0000e+00   beta0=3.0000e+01 \
  dvt0w=3.0490e-01   dvt1w=2.3530e+05   dvt2w=-2.685e+00 \
     ua=5.6220e-12      ub=9.5730e-19      uc=7.1200e-13 \
u0=4.7000e+02+(4.7000e+02)*dumat \
   dsub=5.2500e+00    eta0=1.0000e-07    etab=-3.000e-01 \
nfactor=9.0620e-01 \
     em=4.1000e+07    pclm=2.8550e+00 \
  drout=5.0000e-01 \
     a0=8.2080e-01      a1=0.0000e+00      a2=1.0000e+00 \
   pvag=0.0000e+00    vsat=8.9380e+04     ags=1.8620e-02      b0=3.0590e-09      b1=2.6720e-02 \
  delta=3.7770e-05 pdiblcb=1.0000e-12 \
pdiblc1=5.1750e-04 pdiblc2=3.7770e-07 \
     w0=-4.630e-06 \
    dlc=-3.250e-07 \
    dwc=2.7390e-07     dwb=0.0000e+00     dwg=0.0000e+00 \
     ll=0.0000e+00      lw=0.0000e+00     lwl=0.0000e+00 \
    lln=1.0000e+00     lwn=1.0000e+00      wl=0.0000e+00 \
     ww=0.0000e+00     wwl=0.0000e+00     wln=1.0000e+00 \
    wwn=1.0000e+00 \
     at=3.3000e+04     ute=-1.710e+00 \
    kt1=-4.600e-01     kt2=2.2000e-02    kt1l=0.0000e+00 \
    ua1=0.0000e+00     ub1=0.0000e+00     uc1=0.0000e+00 \
    prt=0.0000e+00 \
   cgso=9.2820e-11    cgdo=1.0000e-15    cgbo=1.1000e-10 \
   cgdl=5.0000e-10    cgsl=4.8800e-10  ckappa=1.9890e+00 \
     cf=0.0000e+00     elm=5.0000e+00 \
  xpart=5.0000e-01     clc=1.0000e-15     cle=6.0000e-01 \
\
   rdsw=0.0000e+00 \
   cdsc=1.9360e-06   cdscb=1.0000e-12   cdscd=1.0740e-08 \
   prwb=0.0000e+00    prwg=0.0000e+00     cit=1.0740e-06 \
tox=1.5000e-08 \
  ngate=0.0000e+00 \
    nlx=2.6040e-07 \
     xl=0.0000e+00      xw=0.0000e+00 \
     af=1.9886e+00      kf=1.6086e-24      ef=1.0000e+00 \
   noia=2.5794e+19    noib=1.0199e+05    noic=-2.372e-12 \
     rd=0.0000e+00      rs=0.0000e+00     rsh=7.5000e+01 \
   minr=1.000e-03 \
    rdc=0.0000e+00     rsc=0.0000e+00 lint=-2.271e-07 \
wint=2.7390e-07   ldif=0.000e+00    hdif=8.0000e-07 \
     xj=9.0000e-07      js=3.5530e-07 \
      n=1.0000e+00 \
  dskip=no          tlev=0           tlevc=0         \
    jsw=1.7560e-12 \
     cj=6.3000e-04    cjsw=1.8750e-10 \
     fc=0.0000e+00    fcsw=0.000e+00 \
     mj=3.4000e-01    mjsw=2.3000e-01 \
     pb=6.9000e-01    pbsw=6.9000e-01     xti=2.0260e+00
ends modn30m
// HV-jfet 1
inline subckt modn30mjfet1 (d b s)
parameters w=1e-6
modn30mjfet1 (d b s) rnjfetinsub
model rnjfetinsub jfet type=n \
beta=4.4210e+00/(1+(2.8000e-03)*(temp-(2.7000e+01)))*(w+(1.6670e-06))/(1+(6.0000e-03)*(temp-27)) \
vto=-5.700e+00*(1+(2.8000e-03)*(temp-(2.7000e+01))) \
lambda=0.0000e+00 \
is=0.0000e+00  pb=5.0000e-01 \
cgs=0.0000e+00 rs=0.0000e+00 \
cgd=0.0000e+00 rd=0.0000e+00
ends modn30mjfet1
// HV-jfet 2
inline subckt  modn30mjfet2 (d b s)
parameters w=1e-6
modn30mjfet2 (d b s) rnjfetinsub
model rnjfetinsub jfet type=n \
beta=4.4900e+00/(1+(2.8000e-03)*(temp-(2.7000e+01)))*(w+(1.6670e-06))/(1+(6.0000e-03)*(temp-27)) \
vto=-7.957e+00*(1+(2.8000e-03)*(temp-(2.7000e+01))) \
lambda=0.0000e+00 \
is=0.0000e+00  pb=5.0000e-01 \
cgs=0.0000e+00 rs=0.0000e+00 \
cgd=0.0000e+00 rd=0.0000e+00
ends modn30mjfet2
//

inline subckt modn30mnwd ( a c )
parameters area=1.0e-12 perimeter=1.0e-6
modn30mnwd ( a c ) diodeinsub area=area perim=perimeter region=off
model diodeinsub diode level=1 dskip=no \
is=1.676e-06          isw=2.158e-11                n=1.000e+00 ns=1.000e+00 \
minr=0.100e+00   imax=(1.000e+00/area) \
cj0=8.798e-05        m=2.737e-01                  vj=5.300e-01 tt=0.000e+00 \
cjsw=6.611e-10       mjsw=2.122e-01             vjsw=5.300e-01 fc=0.000e+00\
af=1.000e+00     kf=0.000e+00            xti=1.366e+00
ends modn30mnwd
// ----------------------------------------------------------------------
// Owner: austriamicrosystems
// HIT-Kit: Digital
// ************************ SIMULATION PARAMETERS ************************
//  ----------------------------------------------------------------------
//  format    : Spectre (Spectre Direct)
//  model     : MOS BSIM3v3
//  process   : c35
//  revision  : ;
//  extracted : B58737.W09PE6; 2008-06; kmo(5966)
//  doc#      : ENG-327 Rev.2.0
//  ----------------------------------------------------------------------
//                        WORST CASE ONE CONDITION
//  ----------------------------------------------------------------------
//  HV-TRANSISTOR
//  ----------------------------------------------------------------------
inline subckt modn18t ( d g s b )
// Parameters: w l nrd nrs ad as pd ps
parameters w=1.0e-6 l=1.0e-6 nrd=0.0 nrs=0.0 ad=0.0 as=0.0 pd=0.0 ps=0.0 mult=1 gv=(2.8290e-07/l + 8.9230e-01) dcdc=1
+ dvthmat=mv_modn18t*(0.78e-08/sqrt(l*w*mult)) dumat=mu_modn18t*(6.9e-09/sqrt(l*w*mult))
if (modn18t==1){
//
modn18t ( d1 g s1 b ) mosinsub w=w l=l nrd=0 nrs=8.0000e-07/w ad=0 as=as pd=0 ps=ps
rd ( d1 d ) resistor r=(9.9540e-01/(w+(2.4730e-06))) tc1=5.0000e-03
xj1 ( d gj d1 ) modn18tjfet1 w=w
xj2 ( d gj d1 ) modn18tjfet2 w=w
e1 ( d1 gj d1 s ) vcvs gain=gv min=-25 max=25
cgdx ( g d ) capacitor c=(3.8133e-10*w)
v1 ( s1 s ) vsource dc=0 type=dc
i1 ( d b ) bsource i=((5.3850e-10)/(l+(0.0000e+00))+(4.8260e-03))*i("v1:p")*(max((v(d,g)+(2.9600e-02)),1e-15))**(3.8580e+00)*exp((-4.2900e+00)/max((v(d,g)+(2.9600e-02)),1e-10))*(w+0.0000e+00)/w/(1+3.3810e+04*exp(5.3330e-03*i("v1:p")/(w+0.0000e+00)))
xdw ( b d1 ) modn18tnwd area=(1e-06*2.35*(w+1e-06*16)) perimeter=(4e-06*2.35+(w+1e-06*16))
}else
modn18t ( d s ) resistor r=1e30
notvalid paramtest errorif=(modn18t==0) \
message="
***************************************************
*
* nmos18t is not valid in selected process option.
*
***************************************************"
//
model mosinsub bsim3v3 version=3.1 type=n  capmod=2.0000e+00 \
 mobmod=1.0000e+00  nqsmod=0.0000e+00  noimod=3.0000e+00 \
   vbox=1.000e+03      k1=5.4290e-01 \
     k2=-2.609e-03      k3=-2.570e+00     k3b=1.9850e+00 \
    nch=1.7690e+17 vth0=3.8760e-01+dvthmat \
   voff=-8.829e-02    dvt0=1.8190e-01    dvt1=1.0200e-01 \
   dvt2=-5.409e-02    keta=-3.582e-02 \
 pscbe1=3.5770e+12  pscbe2=5.7730e-12 \
 alpha0=0.0000e+00   beta0=3.0000e+01 \
  dvt0w=7.9230e-01   dvt1w=6.0330e+05   dvt2w=-2.792e+00 \
     ua=2.1750e-10      ub=4.8850e-19      uc=1.2070e-10 \
u0=4.1300e+02+(4.1300e+02)*dumat \
   dsub=5.2500e+00    eta0=1.0000e-07    etab=-3.000e-01 \
nfactor=8.6770e-01 \
     em=4.1000e+07    pclm=6.0510e+00 \
  drout=5.0000e-01 \
     a0=7.6440e-01      a1=0.0000e+00      a2=1.0000e+00 \
   pvag=0.0000e+00    vsat=5.5760e+04     ags=2.3440e-01      b0=4.4050e-09      b1=2.6720e-02 \
  delta=2.5490e-05 pdiblcb=1.0000e-12 \
pdiblc1=2.2650e+00 pdiblc2=1.0000e-09 \
     w0=-7.990e-01 \
    dlc=-5.050e-07 \
    dwc=1.6680e-07     dwb=0.0000e+00     dwg=0.0000e+00 \
     ll=0.0000e+00      lw=0.0000e+00     lwl=0.0000e+00 \
    lln=1.0000e+00     lwn=1.0000e+00      wl=0.0000e+00 \
     ww=0.0000e+00     wwl=0.0000e+00     wln=1.0000e+00 \
    wwn=1.0000e+00 \
     at=3.3000e+04     ute=-1.720e+00 \
    kt1=-3.210e-01     kt2=2.2000e-02    kt1l=0.0000e+00 \
    ua1=0.0000e+00     ub1=0.0000e+00     uc1=0.0000e+00 \
    prt=0.0000e+00 \
   cgso=1.0183e-10    cgdo=1.0000e-15    cgbo=1.1000e-10 \
   cgdl=4.4020e-10    cgsl=5.0000e-10  ckappa=6.2280e-01 \
     cf=0.0000e+00     elm=5.0000e+00 \
  xpart=5.0000e-01     clc=1.0000e-15     cle=6.0000e-01 \
\
   rdsw=0.0000e+00 \
   cdsc=5.0330e-20   cdscb=2.9060e-04   cdscd=7.3780e-10 \
   prwb=0.0000e+00    prwg=0.0000e+00     cit=7.3780e-08 \
tox=7.6000e-09 \
  ngate=0.0000e+00 \
    nlx=1.4630e-07 \
     xl=0.0000e+00      xw=0.0000e+00 \
     af=2.0045e+00      kf=8.5977e-25      ef=1.0000e+00 \
   noia=4.8618e+18    noib=2.9560e+04    noic=-2.148e-13 \
     rd=0.0000e+00      rs=0.0000e+00     rsh=7.5000e+01 \
   minr=1.000e-03 \
    rdc=0.0000e+00     rsc=0.0000e+00 lint=-3.414e-07 \
wint=1.6680e-07   ldif=0.000e+00    hdif=8.0000e-07 \
     xj=9.0000e-07      js=3.5530e-07 \
      n=1.0000e+00 \
  dskip=no          tlev=0           tlevc=0         \
    jsw=1.7560e-12 \
     cj=6.3000e-04    cjsw=1.8750e-10 \
     fc=0.0000e+00    fcsw=0.000e+00 \
     mj=3.4000e-01    mjsw=2.3000e-01 \
     pb=6.9000e-01    pbsw=6.9000e-01     xti=2.0260e+00
ends modn18t
// HV-jfet 1
inline subckt modn18tjfet1 (d b s)
parameters w=1e-6
modn18tjfet1 (d b s) rnjfetinsub
model rnjfetinsub jfet type=n \
beta=4.0710e+00/(1+(1.6000e-03)*(temp-(2.7000e+01)))*(w+(2.4730e-06))/(1+(5.0000e-03)*(temp-27)) \
vto=-7.402e+00*(1+(1.6000e-03)*(temp-(2.7000e+01))) \
lambda=0.0000e+00 \
is=0.0000e+00  pb=5.0000e-01 \
cgs=0.0000e+00 rs=0.0000e+00 \
cgd=0.0000e+00 rd=0.0000e+00
ends modn18tjfet1
// HV-jfet 2
inline subckt  modn18tjfet2 (d b s)
parameters w=1e-6
modn18tjfet2 (d b s) rnjfetinsub
model rnjfetinsub jfet type=n \
beta=1.9980e+00/(1+(1.6000e-03)*(temp-(2.7000e+01)))*(w+(2.4730e-06))/(1+(5.0000e-03)*(temp-27)) \
vto=-7.947e+00*(1+(1.6000e-03)*(temp-(2.7000e+01))) \
lambda=0.0000e+00 \
is=0.0000e+00  pb=5.0000e-01 \
cgs=0.0000e+00 rs=0.0000e+00 \
cgd=0.0000e+00 rd=0.0000e+00
ends modn18tjfet2
//

inline subckt modn18tnwd ( a c )
parameters area=1.0e-12 perimeter=1.0e-6
modn18tnwd ( a c ) diodeinsub area=area perim=perimeter region=off
model diodeinsub diode level=1 dskip=no \
is=2.159e-06          isw=3.227e-11                n=1.000e+00 ns=1.000e+00 \
minr=0.100e+00   imax=(1.000e+00/area) \
cj0=8.992e-05        m=2.671e-01                  vj=5.300e-01 tt=0.000e+00 \
cjsw=6.406e-10       mjsw=2.161e-01             vjsw=5.300e-01 fc=0.000e+00\
af=1.000e+00     kf=0.000e+00            xti=4.786e-01
ends modn18tnwd

// ----------------------------------------------------------------------
// Owner: austriamicrosystems
// HIT-Kit: Digital
// ************************ SIMULATION PARAMETERS ************************
//  ----------------------------------------------------------------------
//  format    : Spectre (Spectre Direct)
//  model     : MOS HiSIM_HV
//  process   : c35
//  revision  : REVISION 3.0 Wafer C50118W01 2013/12/12;
//  extracted : MCT;
//  doc#      : Eng-327 REV 5.0
//  ----------------------------------------------------------------------
//                        WORST CASE ONE CONDITION
//  ----------------------------------------------------------------------
//
// UNSYMMETRIC HV-TRANSISTOR WITH EXTENDED PARASITICS
// PARAMS: NRD NRS AD AS PD PS AW PW (SEE NETLIST FORMAT DOC.)
// NMOS: N-Well Diode
// PMOS: P-Well Diode + PSUB+Diode
//  ----------------------------------------------------------------------
inline subckt modpd30m ( d g s b psub )
// Parameters: w l nrd nrs ad as pd ps
parameters w=1.0e-6 l=1.0e-6 nrd=0.0 nrs=0.0 ad=0.0 as=0.0 pd=0.0 ps=0.0 mult=1 dtemp=0
+ isoVoltage=50
+ dvthmat=(mv_modpd30m)*(1.73e-08/sqrt(l*w*mult)) dumat=(mu_modpd30m)*(6.15e-09/sqrt(l*w*mult))
if (modpd30m==1){
modpd30m ( d g s b ) mosinsub w=w l=l nrd=0 nrs=8.0000e-07/w ad=0 as=as pd=0 ps=ps
xpd ( d b ) modpd30mpd area=w*3.7e-06 perimeter=3.7e-06*2*mult
xnwd ( psub b ) modpd30mnwd area=(w+1e-06*23.6)*(l+1e-06*8.25) perimeter=4*(l+1e-06*8.25)+(w+1e-06*23.6)
}else
modpd30m ( d s ) resistor r=1e30
notvalid paramtest errorif=(modpd30m==0) \
message="
***************************************************
*
* pmosd30m is not valid in selected process option.
*
***************************************************"
//
model mosinsub hisim_hv version=1.230e+00 type=p \
 corsrd=3.0000e+00  coovlp=1.0000e+00 coovlps=1.0000e+00 \
 coisub=0.0000e+00  coiigs=0.0000e+00  cogidl=0.0000e+00 \
 coisti=0.0000e+00  coadov=1.0000e+00   conqs=0.0000e+00 \
   corg=0.0000e+00 corbnet=0.0000e+00 coflick=1.0000e+00 \
cothrml=1.0000e+00   coign=0.0000e+00  coiprv=1 \
  codfm=0.0000e+00 coselfheat=1.0000e+00   cosym=0.0000e+00  \
cosubnode=0.0000e+00  cotemp=0.0000e+00 coldrift=1.0000e+00 \
coqovsm=1.0000e+00  shemax=5.0000e+02  copprv=1.0000e+00
***************************************************************************
*                             Extension to LDMOS                          *
***************************************************************************
+loverld=4.5000e-07   lover=4.9860e-08 ldrift1=1.0000e-06 \
ldrift2=1.0000e-06  novers=1.8290e+17   nover=2.0600e+17
***************************************************************************
*                                   Charges                               *
***************************************************************************
+     xl=0.0000e+00      xw=5.3321e-11     xld=0.0000e+00 \
  xldld=-3.000e-07     xwd=1.6634e-06    xwdc=0.0000e+00   xwdld=0.0000e+00 \
     ll=0.0000e+00     lld=0.0000e+00     lln=0.0000e+00      wl=0.0000e+00 \
    wld=0.0000e+00     wln=0.0000e+00      vfbc=-4.271e-01+dvthmat \
    vbi=1.1000e+00      tox=1.5000e-08    ddltmax=2.4843e+00 \
ddltslp=0.0000e+00 ddltict=1.0000e+01   kappa=3.9000e+00
***************************************************************************
*                          Threshold Voltage Shift                        *
***************************************************************************
+  parl2=1.0000e-08      sc1=1.2113e+01     sc2=5.0000e-02 \
    sc3=0.0000e+00     sc4=0.0000e+00  pthrou=0.0000e+00 \
     nsubp=1.3074e+17      lp=1.3447e-07     bs1=0.0000e+00 \
    bs2=9.0000e-01    scp1=1.5395e+00    scp2=1.0000e-01 \
   scp3=0.0000e+00   scp21=0.0000e+00   scp22=0.0000e+00 \
  npext=1.0000e+17   lpext=1.0000e-50
***************************************************************************
*                   Depletion Effect of the Gate Poly-Si                  *
***************************************************************************
+   pgd1=0.0000e+00    pgd2=1.0000e+00    pgd3=8.0000e-01 \
   pgd4=0.0000e+00
***************************************************************************
*                       Quantum Mechanical Effects                        *
***************************************************************************
+   qme1=0.0000e+00    qme2=1.0000e+00    qme3=0.0000e+00
***************************************************************************
*                            Mobility Model                               *
***************************************************************************
+muecb0=1.0000e+02*(1+dumat)     muecb1=7.5427e+01*(1+dumat) mueph0=3.0000e-01 \
mueph1=7.1797e+03*(1+dumat) muephl=-1.230e-01  mueplp=1.0000e+00 \
 muesr0=2.2790e+00      muesr1=8.6146e+15*(1+dumat) muesrl=-1.087e-01 \
 mueslp=1.0000e+00    ndep=1.0000e+00   ndepl=0.0000e+00 \
 ndeplp=1.0000e+00    ninv=5.0000e-01   ninvd=0.0000e+00 \
     bb=1.0000e+00     vmax=6.4148e+06 \
  vover=3.2667e+00 \
 voverp=2.0000e+00
***************************************************************************
*                        Channel Length Modulation                        *
***************************************************************************
+   clm1=5.0000e-01    clm2=4.0000e+00    clm3=1.0000e+00 \
   clm5=1.0000e+00    clm6=0.0000e+00
***************************************************************************
*                          Narrow Channel Effects                         *
***************************************************************************
+    wfc=0.0000e+00   wvth0=-2.159e-01     nsubc=6.6949e+16 \
 nsubcw=0.0000e+00 nsubcwp=1.0000e+00  nsubp0=0.0000e+00 \
 nsubwp=1.0000e+00  muephw=4.5673e+00  muepwp=1.0000e+00 \
 muesrw=7.8626e-02  mueswp=1.0000e+00  vthsti=0.0000e+00 \
  vdsti=0.0000e+00  scsti1=0.0000e+00  scsti2=0.0000e+00 \
   nsti=1.0000e+17    wsti=0.0000e+00   wstil=0.0000e+00 \
 wstilp=1.0000e+00   wstiw=0.0000e+00  wstiwp=1.0000e+00 \
    wl1=0.0000e+00    wl1p=1.0000e+00     wl2=-1.938e-01 \
   wl2p=1.0000e+00  muephs=-5.777e-01  muepsp=1.0000e+00 \
 vovers=-1.000e-01 voversp=0.0000e+00
***************************************************************************
*                          Source/Drain Diffusion                         *
***************************************************************************
+nsubpsti1=0.0000e+00 nsubpsti2=0.0000e+00 nsubpsti3=1.0000e+00 \
muesti1=0.0000e+00 muesti2=0.0000e+00 muesti3=1.0000e+00 \
  saref=1.0000e-06   sbref=1.0000e-06
***************************************************************************
*                         Temperature Dependencies                        *
***************************************************************************
+    eg0=1.1790e+00  bgtmp1=9.0255e-05  bgtmp2=-2.432e-07 \
 muetmp=1.2226e+00    tnom=2.7000e+01    vtmp=3.6866e-01 \
   egig=0.0000e+00 igtemp2=0.0000e+00 igtemp3=0.0000e+00 \
rdtemp1=3.4836e-04 rdtemp2=2.6548e-06 rdvdtemp1=-5.189e-04 \
rdvdtemp2=9.7855e-07
***************************************************************************
*                                Resistances                              *
***************************************************************************
    +rd=8.4693e-03      rs=0.0000e+00     rsh=0.0000e+00 \
   rshg=0.0000e+00    rbpb=5.0000e+01    rbpd=5.0000e+01 \
   rbps=5.0000e+01 \
 rdvg11=6.4018e+00  rdvg12=1.6108e+01     rdvd=9.0086e-02 \
   rdvb=7.4912e-02     rds=-7.748e-01    rdsp=1.0000e+00 \
  rdvdl=0.0000e+00   rdvds=-4.921e-01  rdvdsp=1.0000e+00 \
 rdov11=0.0000e+00  rdov12=1.0000e+00  rdov13=1.0000e+00 \
 rdslp1=0.0000e+00    rd20=0.0000e+00    rd21=1.0000e+00 \
   rd22=-1.312e-01   rd22d=0.0000e+00     rd23=3.7023e-01 \
  rd23l=5.6859e-01  rd23lp=1.0000e+00   rd23s=-1.675e+00 \
 rd23sp=1.0000e+00    rd24=0.0000e+00    rd25=0.0000e+00 \
  gbmin=1.0000e-12
***************************************************************************
*                                Capacitances                             *
***************************************************************************
+    xqy=0.0000e+00    xqy1=0.0000e+00    xqy2=2.0000e+00 \
vfbover=-1.000e+00   qovsm=2.0000e-01   ovslp=2.0000e-08 \
  ovmag=5.0000e+02    cgso=2.2537e-10    cgdo=4.1697e-10 \
   cgbo=1.1000e-10   tpoly=2.0000e-07
***************************************************************************
*                              Leakage Currents                           *
***************************************************************************
+   sub1=5.0000e-02   sub1l=2.5000e-03  sub1lp=1.0000e+00 \
   sub2=3.0048e+01   sub2l=2.0000e-06    svds=8.0000e-01 \
    slg=3.0000e-08    slgl=0.0000e+00   slglp=1.0000e+00 \
   svbs=5.0000e-01   svbsl=0.0000e+00  svbslp=1.0000e+00 \
   svgs=8.0000e-01   svgsl=0.0000e+00  svgslp=1.0000e+00 \
  svgsw=0.0000e+00  svgswp=1.0000e+00   ibpc1=0.0000e+00 \
  ibpc2=0.0000e+00  subld1=0.0000e+00  subld2=0.0000e+00 \
 gleak1=5.0000e+01  gleak2=1.0000e+07  gleak3=6.0000e-02 \
 gleak4=4.0000e+00  gleak5=7.5000e+03  gleak6=2.5000e-01 \
 gleak7=1.0000e-06   glkb1=5.0000e-16   glkb2=1.0000e+00 \
  glkb3=0.0000e+00  glksd1=1.0000e-15  glksd2=1.0000e-02 \
 glksd3=-1.000e-02 glpart1=5.0000e-01     fn1=0.0000e+00 \
    fn2=0.0000e+00     fn3=0.0000e+00    fvbs=0.0000e+00 \
  gidl1=2.0000e+00   gidl2=3.0000e+07   gidl3=9.0000e-01 \
  gidl4=9.0000e-01   gidl5=2.0000e-01
***************************************************************************
*                             S/B and D/B Diodes                          *
***************************************************************************
+    js0=3.0890e-07   js0sw=1.1310e-13      nj=1.0000e+00 \
   njsw=1.0000e+00     xti=3.8400e+00    xti2=3.8400e+00 \
   divx=0.0000e+00    cisb=0.0000e+00     cvb=0.0000e+00 \
  ctemp=0.0000e+00   cisbk=0.0000e+00    cvbk=0.0000e+00 \
     cj=1.1968e-03    cjsw=3.0800e-10   cjswg=3.5000e-10 \
     mj=5.4000e-01    mjsw=4.6000e-01   mjswg=4.6000e-01 \
     pb=1.0200e+00    pbsw=1.0200e+00   pbswg=1.0200e+00 \
 vdiffj=6.0000e-04
***************************************************************************
*                                   Noise                                 *
***************************************************************************
+  nftrp=3.2435e+07   nfalp=1.5485e-18     cit=0.0000e+00 \
  falph=1.0000e+00
***************************************************************************
*                           Non Quasi Static Model                        *
***************************************************************************
+   dly1=1.0000e-10    dly2=7.0000e-01    dly3=8.0000e-07 \
  dlyov=0.0000e+00
***************************************************************************
*                            Self heating Effect                          *
***************************************************************************
+   rth0=5.5684e-01    cth0=1.0000e-07   rth0w=-8.500e+00 \
 rth0wp=1.0000e+00  rth0nf=0.0000e+00
***************************************************************************
*                                   DFM                                   *
***************************************************************************
+ mphdfm=-3.000e-01
***************************************************************************
*                         Additional Node                                 *
***************************************************************************
+ pzadd0=5.0000e-03  vzadd0=1.0000e-02 \
 rdict1=1.0000e+00  rdict2=0.0000e+00  rdvdlp=1.0000e+00 \
 vbsmin=-1.050e+01  rdslp2=1.0000e+00
***************************************************************************
*                         Additional Node                                 *
***************************************************************************
+ rdvsub=3.0000e-01 rdvdsub=1.0000e+00  ddrift=1.0000e-06 \
 vbisub=7.0000e-01 nsubsub=1.0000e+15
ends modpd30m
//

inline subckt modpd30mpd ( a c )
parameters area=1.0e-12 perimeter=1.0e-6
modpd30mpd ( a c ) diodeinsub area=area perim=perimeter region=off
model diodeinsub diode level=1 dskip=no \
  is=6.1140e-07          isw=2.4910e-13 \
   n=1.0400e+00           ns=1.0400e+00 \
minr=0.100e+00          imax=(1.000e+00/area) \
 cj0=1.2340e-03           m=6.2660e-01 \
  vj=1.0200e+00           tt=0.000e+00 \
cjsw=2.8230e-10         mjsw=4.8760e-01 \
vjsw=1.0200e+00           fc=0.000e+00 \
  af=1.000e+00             kf=0.000e+00 \
 xti=2.7630e+00
ends modpd30mpd
//

inline subckt modpd30mnwd ( a c )
parameters area=1.0e-12 perimeter=1.0e-6
modpd30mnwd ( a c ) diodeinsub area=area perim=perimeter region=off
model diodeinsub diode level=1 dskip=no \
  is=7.101e-06          isw=5.386e-12 \
   n=1.000e+00      ns=1.000e+00 \
minr=0.100e+00    imax=(1.000e+00/area) \
 cj0=3.850e-04           m=2.982e-01 \
  vj=5.300e-01          vjsw=5.300e-01 \
  fc=0.000e+00        tt=0.000e+00 \
cjsw=0.000e+00       mjsw=4.401e-01 \
  af=1.000e+00     kf=0.000e+00 \
 xti=-3.138e+00
ends modpd30mnwd

// ----------------------------------------------------------------------
// Owner: austriamicrosystems
// HIT-Kit: Digital
// ************************ SIMULATION PARAMETERS ************************
//  ----------------------------------------------------------------------
//  format    : Spectre (Spectre Direct)
//  model     : MOS HiSIM_HV
//  process   : c35
//  revision  : REVISION 1.0 Wafer C50118W01 2013/12/12;
//  extracted : MCT;
//  doc#      : Eng-327 REV 5.0
//  ----------------------------------------------------------------------
//                        WORST CASE ONE CONDITION
//  ----------------------------------------------------------------------
//
// UNSYMMETRIC HV-TRANSISTOR WITH EXTENDED PARASITICS
// PARAMS: NRD NRS AD AS PD PS AW PW (SEE NETLIST FORMAT DOC.)
// NMOS: N-Well Diode
// PMOS: P-Well Diode + PSUB+Diode
//  ----------------------------------------------------------------------
inline subckt modp30m ( d g s b psub )
// Parameters: w l nrd nrs ad as pd ps
parameters w=1.0e-6 l=1.0e-6 nrd=0.0 nrs=0.0 ad=0.0 as=0.0 pd=0.0 ps=0.0 mult=1 dtemp=0
+ isoVoltage=50
+ dvthmat=(mv_modp30m)*(1.73e-08/sqrt(l*w*mult)) dumat=(mu_modp30m)*(6.15e-09/sqrt(l*w*mult))
if (modp30m==1){
modp30m ( d g s b ) mosinsub w=w l=l nrd=0 nrs=8.0000e-07/w ad=0 as=as pd=0 ps=ps
xpd ( d b ) modp30mpd area=w*3.7e-06 perimeter=3.7e-06*2*mult
xnwd ( psub b ) modp30mnwd area=(w+1e-06*23.6)*(l+1e-06*8.25) perimeter=4*(l+1e-06*8.25)+(w+1e-06*23.6)
}else
modp30m ( d s ) resistor r=1e30
notvalid paramtest errorif=(modp30m==0) \
message="
***************************************************
*
* pmosd30m is not valid in selected process option.
*
***************************************************"
//
model mosinsub hisim_hv version=1.230e+00 type=p \
 corsrd=3.0000e+00  coovlp=1.0000e+00 coovlps=1.0000e+00 \
 coisub=0.0000e+00  coiigs=0.0000e+00  cogidl=0.0000e+00 \
 coisti=0.0000e+00  coadov=1.0000e+00   conqs=0.0000e+00 \
   corg=0.0000e+00 corbnet=0.0000e+00 coflick=1.0000e+00 \
cothrml=1.0000e+00   coign=0.0000e+00  coiprv=1 \
  codfm=0.0000e+00 coselfheat=1.0000e+00   cosym=0.0000e+00  \
cosubnode=0.0000e+00  cotemp=0.0000e+00 coldrift=1.0000e+00 \
coqovsm=1.0000e+00  shemax=5.0000e+02  copprv=1.0000e+00
***************************************************************************
*                             Extension to LDMOS                          *
***************************************************************************
+loverld=4.5000e-07   lover=4.9860e-08 ldrift1=1.0000e-06 \
ldrift2=1.0000e-06  novers=1.8290e+17   nover=2.0600e+17
***************************************************************************
*                                   Charges                               *
***************************************************************************
+     xl=0.0000e+00      xw=5.3321e-11     xld=0.0000e+00 \
  xldld=-3.000e-07     xwd=1.6634e-06    xwdc=0.0000e+00   xwdld=0.0000e+00 \
     ll=0.0000e+00     lld=0.0000e+00     lln=0.0000e+00      wl=0.0000e+00 \
    wld=0.0000e+00     wln=0.0000e+00      vfbc=-4.271e-01+dvthmat \
    vbi=1.1000e+00      tox=1.5000e-08    ddltmax=2.4843e+00 \
ddltslp=0.0000e+00 ddltict=1.0000e+01   kappa=3.9000e+00
***************************************************************************
*                          Threshold Voltage Shift                        *
***************************************************************************
+  parl2=1.0000e-08      sc1=1.2113e+01     sc2=5.0000e-02 \
    sc3=0.0000e+00     sc4=0.0000e+00  pthrou=0.0000e+00 \
     nsubp=1.3074e+17      lp=1.3447e-07     bs1=0.0000e+00 \
    bs2=9.0000e-01    scp1=1.5395e+00    scp2=1.0000e-01 \
   scp3=0.0000e+00   scp21=0.0000e+00   scp22=0.0000e+00 \
  npext=1.0000e+17   lpext=1.0000e-50
***************************************************************************
*                   Depletion Effect of the Gate Poly-Si                  *
***************************************************************************
+   pgd1=0.0000e+00    pgd2=1.0000e+00    pgd3=8.0000e-01 \
   pgd4=0.0000e+00
***************************************************************************
*                       Quantum Mechanical Effects                        *
***************************************************************************
+   qme1=0.0000e+00    qme2=1.0000e+00    qme3=0.0000e+00
***************************************************************************
*                            Mobility Model                               *
***************************************************************************
+muecb0=1.0000e+02*(1+dumat)     muecb1=7.5427e+01*(1+dumat) mueph0=3.0000e-01 \
mueph1=7.1797e+03*(1+dumat) muephl=-1.230e-01  mueplp=1.0000e+00 \
 muesr0=2.2790e+00      muesr1=8.6146e+15*(1+dumat) muesrl=-1.087e-01 \
 mueslp=1.0000e+00    ndep=1.0000e+00   ndepl=0.0000e+00 \
 ndeplp=1.0000e+00    ninv=5.0000e-01   ninvd=0.0000e+00 \
     bb=1.0000e+00     vmax=6.4148e+06 \
  vover=3.2667e+00 \
 voverp=2.0000e+00
***************************************************************************
*                        Channel Length Modulation                        *
***************************************************************************
+   clm1=5.0000e-01    clm2=4.0000e+00    clm3=1.0000e+00 \
   clm5=1.0000e+00    clm6=0.0000e+00
***************************************************************************
*                          Narrow Channel Effects                         *
***************************************************************************
+    wfc=0.0000e+00   wvth0=-2.159e-01     nsubc=6.6949e+16 \
 nsubcw=0.0000e+00 nsubcwp=1.0000e+00  nsubp0=0.0000e+00 \
 nsubwp=1.0000e+00  muephw=4.5673e+00  muepwp=1.0000e+00 \
 muesrw=7.8626e-02  mueswp=1.0000e+00  vthsti=0.0000e+00 \
  vdsti=0.0000e+00  scsti1=0.0000e+00  scsti2=0.0000e+00 \
   nsti=1.0000e+17    wsti=0.0000e+00   wstil=0.0000e+00 \
 wstilp=1.0000e+00   wstiw=0.0000e+00  wstiwp=1.0000e+00 \
    wl1=0.0000e+00    wl1p=1.0000e+00     wl2=-1.938e-01 \
   wl2p=1.0000e+00  muephs=-5.777e-01  muepsp=1.0000e+00 \
 vovers=-1.000e-01 voversp=0.0000e+00
***************************************************************************
*                          Source/Drain Diffusion                         *
***************************************************************************
+nsubpsti1=0.0000e+00 nsubpsti2=0.0000e+00 nsubpsti3=1.0000e+00 \
muesti1=0.0000e+00 muesti2=0.0000e+00 muesti3=1.0000e+00 \
  saref=1.0000e-06   sbref=1.0000e-06
***************************************************************************
*                         Temperature Dependencies                        *
***************************************************************************
+    eg0=1.1790e+00  bgtmp1=9.0255e-05  bgtmp2=-2.432e-07 \
 muetmp=1.2226e+00    tnom=2.7000e+01    vtmp=3.6866e-01 \
   egig=0.0000e+00 igtemp2=0.0000e+00 igtemp3=0.0000e+00 \
rdtemp1=3.4836e-04 rdtemp2=2.6548e-06 rdvdtemp1=-5.189e-04 \
rdvdtemp2=9.7855e-07
***************************************************************************
*                                Resistances                              *
***************************************************************************
    +rd=8.4693e-03      rs=0.0000e+00     rsh=0.0000e+00 \
   rshg=0.0000e+00    rbpb=5.0000e+01    rbpd=5.0000e+01 \
   rbps=5.0000e+01 \
 rdvg11=6.4018e+00  rdvg12=1.6108e+01     rdvd=9.0086e-02 \
   rdvb=7.4912e-02     rds=-7.748e-01    rdsp=1.0000e+00 \
  rdvdl=0.0000e+00   rdvds=-4.921e-01  rdvdsp=1.0000e+00 \
 rdov11=0.0000e+00  rdov12=1.0000e+00  rdov13=1.0000e+00 \
 rdslp1=0.0000e+00    rd20=0.0000e+00    rd21=1.0000e+00 \
   rd22=-1.312e-01   rd22d=0.0000e+00     rd23=3.7023e-01 \
  rd23l=5.6859e-01  rd23lp=1.0000e+00   rd23s=-1.675e+00 \
 rd23sp=1.0000e+00    rd24=0.0000e+00    rd25=0.0000e+00 \
  gbmin=1.0000e-12
***************************************************************************
*                                Capacitances                             *
***************************************************************************
+    xqy=0.0000e+00    xqy1=0.0000e+00    xqy2=2.0000e+00 \
vfbover=-1.000e+00   qovsm=2.0000e-01   ovslp=2.0000e-08 \
  ovmag=5.0000e+02    cgso=2.2537e-10    cgdo=4.1697e-10 \
   cgbo=1.1000e-10   tpoly=2.0000e-07
***************************************************************************
*                              Leakage Currents                           *
***************************************************************************
+   sub1=5.0000e-02   sub1l=2.5000e-03  sub1lp=1.0000e+00 \
   sub2=3.0048e+01   sub2l=2.0000e-06    svds=8.0000e-01 \
    slg=3.0000e-08    slgl=0.0000e+00   slglp=1.0000e+00 \
   svbs=5.0000e-01   svbsl=0.0000e+00  svbslp=1.0000e+00 \
   svgs=8.0000e-01   svgsl=0.0000e+00  svgslp=1.0000e+00 \
  svgsw=0.0000e+00  svgswp=1.0000e+00   ibpc1=0.0000e+00 \
  ibpc2=0.0000e+00  subld1=0.0000e+00  subld2=0.0000e+00 \
 gleak1=5.0000e+01  gleak2=1.0000e+07  gleak3=6.0000e-02 \
 gleak4=4.0000e+00  gleak5=7.5000e+03  gleak6=2.5000e-01 \
 gleak7=1.0000e-06   glkb1=5.0000e-16   glkb2=1.0000e+00 \
  glkb3=0.0000e+00  glksd1=1.0000e-15  glksd2=1.0000e-02 \
 glksd3=-1.000e-02 glpart1=5.0000e-01     fn1=0.0000e+00 \
    fn2=0.0000e+00     fn3=0.0000e+00    fvbs=0.0000e+00 \
  gidl1=2.0000e+00   gidl2=3.0000e+07   gidl3=9.0000e-01 \
  gidl4=9.0000e-01   gidl5=2.0000e-01
***************************************************************************
*                             S/B and D/B Diodes                          *
***************************************************************************
+    js0=3.0890e-07   js0sw=1.1310e-13      nj=1.0000e+00 \
   njsw=1.0000e+00     xti=3.8400e+00    xti2=3.8400e+00 \
   divx=0.0000e+00    cisb=0.0000e+00     cvb=0.0000e+00 \
  ctemp=0.0000e+00   cisbk=0.0000e+00    cvbk=0.0000e+00 \
     cj=1.1968e-03    cjsw=3.0800e-10   cjswg=3.5000e-10 \
     mj=5.4000e-01    mjsw=4.6000e-01   mjswg=4.6000e-01 \
     pb=1.0200e+00    pbsw=1.0200e+00   pbswg=1.0200e+00 \
 vdiffj=6.0000e-04
***************************************************************************
*                                   Noise                                 *
***************************************************************************
+  nftrp=3.2435e+07   nfalp=1.5485e-18     cit=0.0000e+00 \
  falph=1.0000e+00
***************************************************************************
*                           Non Quasi Static Model                        *
***************************************************************************
+   dly1=1.0000e-10    dly2=7.0000e-01    dly3=8.0000e-07 \
  dlyov=0.0000e+00
***************************************************************************
*                            Self heating Effect                          *
***************************************************************************
+   rth0=5.5684e-01    cth0=1.0000e-07   rth0w=-8.500e+00 \
 rth0wp=1.0000e+00  rth0nf=0.0000e+00
***************************************************************************
*                                   DFM                                   *
***************************************************************************
+ mphdfm=-3.000e-01
***************************************************************************
*                         Additional Node                                 *
***************************************************************************
+ pzadd0=5.0000e-03  vzadd0=1.0000e-02 \
 rdict1=1.0000e+00  rdict2=0.0000e+00  rdvdlp=1.0000e+00 \
 vbsmin=-1.050e+01  rdslp2=1.0000e+00
***************************************************************************
*                         Additional Node                                 *
***************************************************************************
+ rdvsub=3.0000e-01 rdvdsub=1.0000e+00  ddrift=1.0000e-06 \
 vbisub=7.0000e-01 nsubsub=1.0000e+15
ends modp30m
//

inline subckt modp30mpd ( a c )
parameters area=1.0e-12 perimeter=1.0e-6
modp30mpd ( a c ) diodeinsub area=area perim=perimeter region=off
model diodeinsub diode level=1 dskip=no \
  is=6.1140e-07          isw=2.4910e-13 \
   n=1.0400e+00           ns=1.0400e+00 \
minr=0.100e+00          imax=(1.000e+00/area) \
 cj0=1.2340e-03           m=6.2660e-01 \
  vj=1.0200e+00           tt=0.000e+00 \
cjsw=2.8230e-10         mjsw=4.8760e-01 \
vjsw=1.0200e+00           fc=0.000e+00 \
  af=1.000e+00             kf=0.000e+00 \
 xti=2.7630e+00
ends modp30mpd
//

inline subckt modp30mnwd ( a c )
parameters area=1.0e-12 perimeter=1.0e-6
modp30mnwd ( a c ) diodeinsub area=area perim=perimeter region=off
model diodeinsub diode level=1 dskip=no \
  is=7.101e-06          isw=5.386e-12 \
   n=1.000e+00      ns=1.000e+00 \
minr=0.100e+00    imax=(1.000e+00/area) \
 cj0=3.850e-04           m=2.982e-01 \
  vj=5.300e-01          vjsw=5.300e-01 \
  fc=0.000e+00        tt=0.000e+00 \
cjsw=0.000e+00       mjsw=4.401e-01 \
  af=1.000e+00     kf=0.000e+00 \
 xti=-3.138e+00
ends modp30mnwd

// ----------------------------------------------------------------------
// Owner: austriamicrosystems
// HIT-Kit: Digital
// ************************ SIMULATION PARAMETERS ************************
//  ----------------------------------------------------------------------
//  format    : Spectre (Spectre Direct)
//  model     : MOS BSIM3v3
//  process   : C35
//  revision  : 1.0;
//  extracted : C18069; 28.08.2011; bse (5866)
//  doc#      : Eng-?? REV_0
//  ----------------------------------------------------------------------
//                         WORST CASE ONE CONDITION
//
//  ----------------------------------------------------------------------
//
inline subckt nmosw_2n ( d g s b )
parameters w=1.0e-6 l=1.0e-6 nrd=0.0 nrs=0.0 ad=0.0 as=0.0 pd=0.0 ps=0.0 ng=1
+ ws= w
+ ls= l
+ shk=1
+ dvthmat=(mv_nmosw_2n)*(0.67e-08/sqrt(ls*ws*ng)) dumat=(mu_nmosw_2n)*(4.9e-9/sqrt(ls*ws*ng))
//
if (modn==1)
nmosw_2n ( d g s b ) mosinsub w=ws l=ls nrd=8.0000e-07/ws nrs=8.0000e-07/ws ad=ad as=as pd=pd ps=ps m=ng
else
nmosw_2n ( d s ) resistor r=1e30
notvalid paramtest errorif=(modn==0) \
message="
***************************************************
*
* nmos is not valid in selected process option.
*
***************************************************"
model mosinsub bsim3v3 version=3.2400e+00  type=n  capmod=3.0000e+00 \
 mobmod=1.0000e+00  nqsmod=0.0000e+00  noimod=3.0000e+00 \
   vbox=1.000e+03      k1=4.6580e-01 \
     k2=0.0000e+00      k3=3.0270e-02     k3b=-1.089e-02 \
    nch=1.9540e+17 vth0=3.5220e-01+dvthmat \
   voff=-7.600e-02    dvt0=2.1160e+01    dvt1=1.0640e+00 \
   dvt2=3.0590e-02    keta=-1.200e-02 \
 pscbe1=1.0000e+30  pscbe2=1.0000e-06 \
 alpha0=1.9040e-06  alpha1=2.5000e+00   beta0=2.0000e+01 \
  dvt0w=2.0000e+00   dvt1w=1.6970e+06   dvt2w=-1.556e-02 \
     ua=-3.981e-10      ub=2.6890e-18      uc=6.9180e-11 \
u0=4.2940e+02+(4.2940e+02)*dumat \
   dsub=5.0000e-01    eta0=1.4790e-02    etab=-5.280e-02 \
nfactor=2.6780e-01 \
     em=4.1000e+07    pclm=9.6570e-01 \
  drout=5.0000e-01 \
     a0=2.0840e+00      a1=0.0000e+00      a2=1.0000e+00 \
   pvag=1.3460e-01    vsat=1.0200e+05     ags=3.6080e-01      b0=5.0200e-08      b1=1.0060e-07 \
  delta=2.3500e-03 pdiblcb=3.2150e-01 \
pdiblc1=1.0800e-01 pdiblc2=1.6220e-03 \
     w0=-3.185e-07 \
    dlc=-1.588e-08 \
dwc=-3.263e-01*l+1.5050e-07    dwb=0.0000e+00     dwg=-9.302e-09 \
     ll=1.0680e-13      lw=0.0000e+00     lwl=0.0000e+00 \
    lln=1.0000e+00     lwn=1.0000e+00      wl=2.8610e-13 \
     ww=-1.130e-14     wwl=-9.411e-21     wln=1.0000e+00 \
     wr=1.0000e+00     wwn=1.0000e+00 \
     at=2.5000e+04     ute=-1.700e+00 \
    kt1=-3.100e-01     kt2=-1.720e-02    kt1l=0.0000e+00 \
    ua1=0.0000e+00     ub1=0.0000e+00     uc1=0.0000e+00 \
    prt=3.0000e+01 \
   cgso=1.0850e-12    cgdo=1.0850e-12    cgbo=1.7000e-08 \
   cgdl=2.6250e-10    cgsl=2.6250e-10  ckappa=2.6020e+00 \
     cf=0.0000e+00     elm=5.0000e+00 \
  xpart=1.0000e+00     clc=1.0000e-15     cle=6.0000e-01 \
\
   rdsw=1.1390e+03 \
   cdsc=0.0000e+00   cdscb=1.5000e-09   cdscd=0.0000e+00 \
   prwb=-5.000e-02    prwg=1.3340e-02     cit=8.0260e-04 \
tox=7.6700e-09 \
  ngate=1.0000e+00 \
    nlx=1.7000e-07 \
     xl=-3.796e-08      xw=0.0000e+00 \
     af=1.3760e+00      kf=3.3960e-26      ef=1.0000e+00 \
   noia=1.3990e+20    noib=2.7070e+05    noic=-4.680e-12 \
     rd=0.0000e+00      rs=0.0000e+00     rsh=6.5000e+01 \
   minr=1.000e-03 \
    rdc=0.0000e+00     rsc=0.0000e+00 lint=-3.098e-07 \
wint=-8.969e-07   ldif=0.000e+00    hdif=8.0000e-07 \
     xj=3.0000e-07      js=5.1000e-07 \
      n=1.0000e+00 \
  dskip=no          tlev=0           tlevc=0         \
    jsw=6.0000e-13 \
     cj=6.2250e-04    cjsw=1.8750e-10 \
     fc=0.0000e+00    fcsw=0.000e+00 \
     mj=3.4000e-01    mjsw=2.3000e-01 \
     pb=6.9000e-01    pbsw=6.9000e-01     xti=2.0300e+00
ends nmosw_2n

// ----------------------------------------------------------------------

// ----------------------------------------------------------------------
// Owner: austriamicrosystems
// HIT-Kit: Digital
// ************************ SIMULATION PARAMETERS ************************
//  ----------------------------------------------------------------------
//  format    : Spectre (Spectre Direct)
//  model     : MOS BSIM3v3
//  process   : C35
//  revision  : 1.0;
//  extracted : C18069; 28.08.2011; bse (5866)
//  doc#      : Eng-?? REV_0
//  ----------------------------------------------------------------------
//                         WORST CASE ONE CONDITION
//
//  ----------------------------------------------------------------------
//
inline subckt nmosw_3n ( d g s b )
parameters w=1.0e-6 l=1.0e-6 nrd=0.0 nrs=0.0 ad=0.0 as=0.0 pd=0.0 ps=0.0 ng=1
+ ws= w
+ ls= l
+ shk=1
+ dvthmat=(mv_nmosw_3n)*(0.67e-08/sqrt(ls*ws*ng)) dumat=(mu_nmosw_3n)*(4.9e-9/sqrt(ls*ws*ng))
//
if (modn==1)
nmosw_3n ( d g s b ) mosinsub w=ws l=ls nrd=8.0000e-07/ws nrs=8.0000e-07/ws ad=ad as=as pd=pd ps=ps m=ng
else
nmosw_3n ( d s ) resistor r=1e30
notvalid paramtest errorif=(modn==0) \
message="
***************************************************
*
* nmos is not valid in selected process option.
*
***************************************************"
model mosinsub bsim3v3 version=3.2400e+00  type=n  capmod=3.0000e+00 \
 mobmod=1.0000e+00  nqsmod=0.0000e+00  noimod=3.0000e+00 \
   vbox=1.000e+03      k1=4.6580e-01 \
     k2=0.0000e+00      k3=3.0270e-02     k3b=-1.089e-02 \
    nch=1.9540e+17 vth0=3.5220e-01+dvthmat \
   voff=-7.600e-02    dvt0=2.1160e+01    dvt1=1.0640e+00 \
   dvt2=3.0590e-02    keta=-1.200e-02 \
 pscbe1=1.0000e+30  pscbe2=1.0000e-06 \
 alpha0=1.9040e-06  alpha1=2.5000e+00   beta0=2.0000e+01 \
  dvt0w=2.0000e+00   dvt1w=1.6970e+06   dvt2w=-1.556e-02 \
     ua=-3.981e-10      ub=2.6890e-18      uc=6.9180e-11 \
u0=4.2940e+02+(4.2940e+02)*dumat \
   dsub=5.0000e-01    eta0=1.4790e-02    etab=-5.280e-02 \
nfactor=2.6780e-01 \
     em=4.1000e+07    pclm=9.6570e-01 \
  drout=5.0000e-01 \
     a0=2.0840e+00      a1=0.0000e+00      a2=1.0000e+00 \
   pvag=1.3460e-01    vsat=1.0200e+05     ags=3.6080e-01      b0=5.0200e-08      b1=1.0060e-07 \
  delta=2.3500e-03 pdiblcb=3.2150e-01 \
pdiblc1=2.3600e-01 pdiblc2=2.4880e-03 \
     w0=-3.185e-07 \
    dlc=-1.588e-08 \
dwc=-3.263e-01*l+1.5050e-07    dwb=0.0000e+00     dwg=-9.302e-09 \
     ll=1.0680e-13      lw=0.0000e+00     lwl=0.0000e+00 \
    lln=1.0000e+00     lwn=1.0000e+00      wl=2.8610e-13 \
     ww=-1.130e-14     wwl=-9.411e-21     wln=1.0000e+00 \
     wr=1.0000e+00     wwn=1.0000e+00 \
     at=2.5000e+04     ute=-1.700e+00 \
    kt1=-3.100e-01     kt2=-1.720e-02    kt1l=0.0000e+00 \
    ua1=0.0000e+00     ub1=0.0000e+00     uc1=0.0000e+00 \
    prt=3.0000e+01 \
   cgso=1.0850e-12    cgdo=1.0850e-12    cgbo=1.7000e-08 \
   cgdl=2.6250e-10    cgsl=2.6250e-10  ckappa=2.6020e+00 \
     cf=0.0000e+00     elm=5.0000e+00 \
  xpart=1.0000e+00     clc=1.0000e-15     cle=6.0000e-01 \
\
   rdsw=1.1390e+03 \
   cdsc=0.0000e+00   cdscb=1.5000e-09   cdscd=0.0000e+00 \
   prwb=-1.471e-01    prwg=1.3340e-02     cit=8.0260e-04 \
tox=7.6700e-09 \
  ngate=1.0000e+00 \
    nlx=1.7000e-07 \
     xl=-3.396e-08      xw=0.0000e+00 \
     af=1.3760e+00      kf=3.3960e-26      ef=1.0000e+00 \
   noia=1.3990e+20    noib=2.7070e+05    noic=-4.680e-12 \
     rd=0.0000e+00      rs=0.0000e+00     rsh=6.5000e+01 \
   minr=1.000e-03 \
    rdc=0.0000e+00     rsc=0.0000e+00 lint=-3.098e-07 \
wint=-8.216e-07   ldif=0.000e+00    hdif=8.0000e-07 \
     xj=3.0000e-07      js=5.1000e-07 \
      n=1.0000e+00 \
  dskip=no          tlev=0           tlevc=0         \
    jsw=6.0000e-13 \
     cj=6.2250e-04    cjsw=1.8750e-10 \
     fc=0.0000e+00    fcsw=0.000e+00 \
     mj=3.4000e-01    mjsw=2.3000e-01 \
     pb=6.9000e-01    pbsw=6.9000e-01     xti=2.0300e+00
ends nmosw_3n

// ----------------------------------------------------------------------

// ----------------------------------------------------------------------
// Owner: austriamicrosystems
// HIT-Kit: Digital
// ************************ SIMULATION PARAMETERS ************************
//  ----------------------------------------------------------------------
//  format    : Spectre (Spectre Direct)
//  model     : MOS BSIM3v3
//  process   : C35
//  revision  : 1.0;
//  extracted : C18069; 28.08.2011; bse (5866)
//  doc#      : Eng-?? REV_0
//  ----------------------------------------------------------------------
//                         WORST CASE ONE CONDITION
//
//  ----------------------------------------------------------------------
//
inline subckt nmosw_4n ( d g s b )
parameters w=1.0e-6 l=1.0e-6 nrd=0.0 nrs=0.0 ad=0.0 as=0.0 pd=0.0 ps=0.0 ng=1
+ ws= w
+ ls= l
+ shk=1
+ dvthmat=(mv_nmosw_4n)*(0.67e-08/sqrt(ls*ws*ng)) dumat=(mu_nmosw_4n)*(4.9e-9/sqrt(ls*ws*ng))
//
if (modn==1)
nmosw_4n ( d g s b ) mosinsub w=ws l=ls nrd=8.0000e-07/ws nrs=8.0000e-07/ws ad=ad as=as pd=pd ps=ps m=ng
else
nmosw_4n ( d s ) resistor r=1e30
notvalid paramtest errorif=(modn==0) \
message="
***************************************************
*
* nmos is not valid in selected process option.
*
***************************************************"
model mosinsub bsim3v3 version=3.2400e+00  type=n  capmod=3.0000e+00 \
 mobmod=1.0000e+00  nqsmod=0.0000e+00  noimod=3.0000e+00 \
   vbox=1.000e+03      k1=4.6580e-01 \
     k2=0.0000e+00      k3=3.0270e-02     k3b=-1.089e-02 \
    nch=1.9540e+17 vth0=3.5220e-01+dvthmat \
   voff=-7.600e-02    dvt0=2.1160e+01    dvt1=1.0640e+00 \
   dvt2=3.0590e-02    keta=-1.200e-02 \
 pscbe1=1.0000e+30  pscbe2=1.0000e-06 \
 alpha0=1.9040e-06  alpha1=2.5000e+00   beta0=2.0000e+01 \
  dvt0w=2.0000e+00   dvt1w=1.6970e+06   dvt2w=-1.556e-02 \
     ua=-3.981e-10      ub=2.5120e-18      uc=6.9180e-11 \
u0=4.2940e+02+(4.2940e+02)*dumat \
   dsub=5.0000e-01    eta0=1.4790e-02    etab=-5.280e-02 \
nfactor=2.6780e-01 \
     em=4.1000e+07    pclm=9.6570e-01 \
  drout=5.0000e-01 \
     a0=2.0840e+00      a1=0.0000e+00      a2=1.0000e+00 \
   pvag=1.3460e-01    vsat=1.0200e+05     ags=3.1620e-01      b0=5.0200e-08      b1=1.0060e-07 \
  delta=2.3500e-03 pdiblcb=3.2150e-01 \
pdiblc1=8.3400e-01 pdiblc2=2.4880e-03 \
     w0=-3.185e-07 \
    dlc=-1.588e-08 \
dwc=-3.263e-01*l+1.5050e-07    dwb=0.0000e+00     dwg=-9.302e-09 \
     ll=0.0000e+00      lw=0.0000e+00     lwl=0.0000e+00 \
    lln=1.0000e+00     lwn=1.0000e+00      wl=-1.924e-13 \
     ww=0.0000e+00     wwl=0.0000e+00     wln=1.0000e+00 \
     wr=1.0000e+00     wwn=1.0000e+00 \
     at=2.5000e+04     ute=-1.700e+00 \
    kt1=-3.100e-01     kt2=-1.720e-02    kt1l=0.0000e+00 \
    ua1=0.0000e+00     ub1=0.0000e+00     uc1=0.0000e+00 \
    prt=-2.456e+02 \
   cgso=1.0850e-12    cgdo=1.0850e-12    cgbo=1.7000e-08 \
   cgdl=2.6250e-10    cgsl=2.6250e-10  ckappa=2.6020e+00 \
     cf=0.0000e+00     elm=5.0000e+00 \
  xpart=1.0000e+00     clc=1.0000e-15     cle=6.0000e-01 \
\
   rdsw=1.1410e+03 \
   cdsc=0.0000e+00   cdscb=1.5000e-09   cdscd=0.0000e+00 \
   prwb=-7.244e-02    prwg=1.1740e-01     cit=8.0260e-04 \
tox=7.6700e-09 \
  ngate=1.0000e+00 \
    nlx=1.7000e-07 \
     xl=-4.190e-08      xw=0.0000e+00 \
     af=1.3760e+00      kf=3.3960e-26      ef=1.0000e+00 \
   noia=1.3990e+20    noib=2.7070e+05    noic=-4.680e-12 \
     rd=0.0000e+00      rs=0.0000e+00     rsh=6.5000e+01 \
   minr=1.000e-03 \
    rdc=0.0000e+00     rsc=0.0000e+00 lint=-1.868e-07 \
wint=-3.544e-07   ldif=0.000e+00    hdif=8.0000e-07 \
     xj=3.0000e-07      js=5.1000e-07 \
      n=1.0000e+00 \
  dskip=no          tlev=0           tlevc=0         \
    jsw=6.0000e-13 \
     cj=6.2250e-04    cjsw=1.8750e-10 \
     fc=0.0000e+00    fcsw=0.000e+00 \
     mj=3.4000e-01    mjsw=2.3000e-01 \
     pb=6.9000e-01    pbsw=6.9000e-01     xti=2.0300e+00
ends nmosw_4n

// ----------------------------------------------------------------------

// ----------------------------------------------------------------------
// Owner: austriamicrosystems
// HIT-Kit: Digital
// ************************ SIMULATION PARAMETERS ************************
//  ----------------------------------------------------------------------
//  format    : Spectre (Spectre Direct)
//  model     : MOS BSIM3v3
//  process   : C35
//  revision  : 1.0;
//  extracted : C18069; 28.08.2011; bse (5866)
//  doc#      : Eng-?? REV_0
//  ----------------------------------------------------------------------
//                         WORST CASE ONE CONDITION
//
//  ----------------------------------------------------------------------
//
inline subckt nmosmw_2n ( d g s b )
parameters w=1.0e-6 l=1.0e-6 nrd=0.0 nrs=0.0 ad=0.0 as=0.0 pd=0.0 ps=0.0 ng=1
+ ws= w
+ ls= l
+ shk=1
+ dvthmat=(mv_nmosmw_2n)*(1.03e-08/sqrt(ls*ws*ng)) dumat=(mu_nmosmw_2n)*(3.5e-9/sqrt(ls*ws*ng))
//
if (modnm==1)
nmosmw_2n ( d g s b ) mosinsub w=ws l=ls nrd=6.0000e-07/ws nrs=6.0000e-07/ws ad=ad as=as pd=pd ps=ps m=ng
else
nmosmw_2n ( d s ) resistor r=1e30
notvalid paramtest errorif=(modnm==0) \
message="
***************************************************
*
* nmosm is not valid in selected process option.
*
***************************************************"
model mosinsub bsim3v3 version=3.2400e+00  type=n  capmod=3.0000e+00 \
 mobmod=1.0000e+00  nqsmod=0.0000e+00  noimod=3.0000e+00 \
   vbox=1.000e+03      k1=8.4760e-01 \
     k2=0.0000e+00      k3=-2.500e+00     k3b=-5.640e-02 \
    nch=1.3360e+17 vth0=6.1630e-01+dvthmat \
   voff=-9.684e-02    dvt0=2.0510e+01    dvt1=1.0610e+00 \
   dvt2=2.5970e-02    keta=3.2000e-02 \
 pscbe1=1.0000e+30  pscbe2=1.0000e-06 \
 alpha0=5.5350e-08  alpha1=1.3930e-01   beta0=1.9570e+01 \
  dvt0w=1.0800e+01   dvt1w=3.0990e+06   dvt2w=1.4520e-01 \
     ua=1.4200e-12      ub=1.7380e-18      uc=5.7540e-11 \
u0=5.7350e+02+(5.7350e+02)*dumat \
   dsub=5.0000e-01    eta0=4.0860e-02    etab=-1.000e-03 \
nfactor=8.6050e-01 \
     em=4.1000e+07    pclm=9.0000e-01 \
  drout=5.0000e-01 \
     a0=1.0000e+00      a1=0.0000e+00      a2=1.0000e+00 \
   pvag=6.0000e-02    vsat=5.3380e+04     ags=1.9140e-01      b0=2.0000e-08      b1=1.0000e-08 \
  delta=1.0000e-02 pdiblcb=9.7980e-01 \
pdiblc1=2.4800e-01 pdiblc2=1.2400e-03 \
     w0=3.3160e-08 \
    dlc=1.3960e-09 \
dwc=-2.884e-01*l+1.4740e-07    dwb=8.6800e-09     dwg=-3.770e-09 \
     ll=7.4510e-14      lw=0.0000e+00     lwl=0.0000e+00 \
    lln=1.0000e+00     lwn=1.0000e+00      wl=-3.626e-13 \
     ww=-1.514e-14     wwl=-1.321e-20     wln=1.0000e+00 \
     wr=1.0000e+00     wwn=1.0000e+00 \
     at=3.3000e+04     ute=-1.720e+00 \
    kt1=-4.180e-01     kt2=-4.560e-02    kt1l=0.0000e+00 \
    ua1=0.0000e+00     ub1=0.0000e+00     uc1=0.0000e+00 \
    prt=0.0000e+00 \
   cgso=1.0050e-10    cgdo=1.0050e-10    cgbo=1.6000e-08 \
   cgdl=9.2000e-11    cgsl=9.2000e-11  ckappa=2.9570e+00 \
     cf=0.0000e+00     elm=5.0000e+00 \
  xpart=1.0000e+00     clc=1.0000e-15     cle=6.0000e-01 \
\
   rdsw=3.0420e+03 \
   cdsc=0.0000e+00   cdscb=2.0000e-03   cdscd=0.0000e+00 \
   prwb=5.0000e-02    prwg=4.3480e-03     cit=0.0000e+00 \
tox=1.5000e-08 \
  ngate=1.0000e+00 \
    nlx=1.5690e-07 \
     xl=-7.795e-08      xw=0.0000e+00 \
     af=1.3580e+00      kf=3.4460e-26      ef=1.0000e+00 \
   noia=1.7020e+20    noib=5.4630e+05    noic=-1.400e-11 \
     rd=0.0000e+00      rs=0.0000e+00     rsh=6.8470e+01 \
   minr=1.000e-03 \
    rdc=0.0000e+00     rsc=0.0000e+00 lint=-3.093e-07 \
wint=-8.560e-07   ldif=0.000e+00    hdif=6.0000e-07 \
     xj=3.0000e-07      js=5.1000e-07 \
      n=1.0000e+00 \
  dskip=no          tlev=0           tlevc=0         \
    jsw=6.0000e-13 \
     cj=6.2250e-04    cjsw=1.8750e-10 \
     fc=0.0000e+00    fcsw=0.000e+00 \
     mj=3.4000e-01    mjsw=2.3000e-01 \
     pb=6.9000e-01    pbsw=6.9000e-01     xti=2.0300e+00
ends nmosmw_2n

// ----------------------------------------------------------------------

// ----------------------------------------------------------------------
// Owner: austriamicrosystems
// HIT-Kit: Digital
// ************************ SIMULATION PARAMETERS ************************
//  ----------------------------------------------------------------------
//  format    : Spectre (Spectre Direct)
//  model     : MOS BSIM3v3
//  process   : C35
//  revision  : 1.0;
//  extracted : C18069; 28.08.2011; bse (5866)
//  doc#      : Eng-?? REV_0
//  ----------------------------------------------------------------------
//                         WORST CASE ONE CONDITION
//
//  ----------------------------------------------------------------------
//
inline subckt nmosmw_3n ( d g s b )
parameters w=1.0e-6 l=1.0e-6 nrd=0.0 nrs=0.0 ad=0.0 as=0.0 pd=0.0 ps=0.0 ng=1
+ ws= w
+ ls= l
+ shk=1
+ dvthmat=(mv_nmosmw_3n)*(1.03e-08/sqrt(ls*ws*ng)) dumat=(mu_nmosmw_3n)*(3.5e-9/sqrt(ls*ws*ng))
//
if (modnm==1)
nmosmw_3n ( d g s b ) mosinsub w=ws l=ls nrd=6.0000e-07/ws nrs=6.0000e-07/ws ad=ad as=as pd=pd ps=ps m=ng
else
nmosmw_3n ( d s ) resistor r=1e30
notvalid paramtest errorif=(modnm==0) \
message="
***************************************************
*
* nmosm is not valid in selected process option.
*
***************************************************"
model mosinsub bsim3v3 version=3.2400e+00  type=n  capmod=3.0000e+00 \
 mobmod=1.0000e+00  nqsmod=0.0000e+00  noimod=3.0000e+00 \
   vbox=1.000e+03      k1=8.4760e-01 \
     k2=0.0000e+00      k3=-2.500e+00     k3b=-5.640e-02 \
    nch=1.3360e+17 vth0=6.1630e-01+dvthmat \
   voff=-9.684e-02    dvt0=2.0510e+01    dvt1=1.0610e+00 \
   dvt2=2.5970e-02    keta=3.2000e-02 \
 pscbe1=1.0000e+30  pscbe2=1.0000e-06 \
 alpha0=5.5350e-08  alpha1=1.3930e-01   beta0=1.9570e+01 \
  dvt0w=1.0800e+01   dvt1w=3.0990e+06   dvt2w=1.4520e-01 \
     ua=1.4200e-12      ub=1.7380e-18      uc=5.7540e-11 \
u0=5.7350e+02+(5.7350e+02)*dumat \
   dsub=5.0000e-01    eta0=4.0860e-02    etab=-1.000e-03 \
nfactor=8.6050e-01 \
     em=4.1000e+07    pclm=9.0000e-01 \
  drout=5.0000e-01 \
     a0=1.0000e+00      a1=0.0000e+00      a2=1.0000e+00 \
   pvag=6.0000e-02    vsat=6.1710e+04     ags=1.9140e-01      b0=2.0000e-08      b1=1.0000e-08 \
  delta=1.0000e-02 pdiblcb=9.7980e-01 \
pdiblc1=1.4000e-01 pdiblc2=1.3490e-03 \
     w0=3.3160e-08 \
    dlc=1.3960e-09 \
dwc=-2.884e-01*l+1.4740e-07    dwb=8.6800e-09     dwg=-3.770e-09 \
     ll=7.4510e-14      lw=0.0000e+00     lwl=0.0000e+00 \
    lln=1.0000e+00     lwn=1.0000e+00      wl=-1.968e-13 \
     ww=-1.514e-14     wwl=-1.321e-20     wln=1.0000e+00 \
     wr=1.0000e+00     wwn=1.0000e+00 \
     at=3.3000e+04     ute=-1.720e+00 \
    kt1=-4.180e-01     kt2=-4.560e-02    kt1l=0.0000e+00 \
    ua1=0.0000e+00     ub1=0.0000e+00     uc1=0.0000e+00 \
    prt=0.0000e+00 \
   cgso=1.0050e-10    cgdo=1.0050e-10    cgbo=1.6000e-08 \
   cgdl=9.2460e-11    cgsl=9.2460e-11  ckappa=2.9570e+00 \
     cf=0.0000e+00     elm=5.0000e+00 \
  xpart=1.0000e+00     clc=1.0000e-15     cle=6.0000e-01 \
\
   rdsw=2.5390e+03 \
   cdsc=0.0000e+00   cdscb=2.0000e-03   cdscd=0.0000e+00 \
   prwb=5.0000e-02    prwg=4.3480e-03     cit=0.0000e+00 \
tox=1.5000e-08 \
  ngate=1.0000e+00 \
    nlx=1.5690e-07 \
     xl=-5.993e-08      xw=0.0000e+00 \
     af=1.3580e+00      kf=3.4460e-26      ef=1.0000e+00 \
   noia=1.7020e+20    noib=5.4630e+05    noic=-1.400e-11 \
     rd=0.0000e+00      rs=0.0000e+00     rsh=6.8470e+01 \
   minr=1.000e-03 \
    rdc=0.0000e+00     rsc=0.0000e+00 lint=-2.609e-07 \
wint=-6.127e-07   ldif=0.000e+00    hdif=6.0000e-07 \
     xj=3.0000e-07      js=5.1000e-07 \
      n=1.0000e+00 \
  dskip=no          tlev=0           tlevc=0         \
    jsw=6.0000e-13 \
     cj=6.2250e-04    cjsw=1.8750e-10 \
     fc=0.0000e+00    fcsw=0.000e+00 \
     mj=3.4000e-01    mjsw=2.3000e-01 \
     pb=6.9000e-01    pbsw=6.9000e-01     xti=2.0300e+00
ends nmosmw_3n

// ----------------------------------------------------------------------

// ----------------------------------------------------------------------
// Owner: austriamicrosystems
// HIT-Kit: Digital
// ************************ SIMULATION PARAMETERS ************************
//  ----------------------------------------------------------------------
//  format    : Spectre (Spectre Direct)
//  model     : MOS BSIM3v3
//  process   : C35
//  revision  : 1.0;
//  extracted : C18069; 28.08.2011; bse (5866)
//  doc#      : Eng-?? REV_0
//  ----------------------------------------------------------------------
//                         WORST CASE ONE CONDITION
//
//  ----------------------------------------------------------------------
//
inline subckt nmosmw_4n ( d g s b )
parameters w=1.0e-6 l=1.0e-6 nrd=0.0 nrs=0.0 ad=0.0 as=0.0 pd=0.0 ps=0.0 ng=1
+ ws= w
+ ls= l
+ shk=1
+ dvthmat=(mv_nmosmw_4n)*(1.03e-08/sqrt(ls*ws*ng)) dumat=(mu_nmosmw_4n)*(3.5e-9/sqrt(ls*ws*ng))
//
if (modnm==1)
nmosmw_4n ( d g s b ) mosinsub w=ws l=ls nrd=6.0000e-07/ws nrs=6.0000e-07/ws ad=ad as=as pd=pd ps=ps m=ng
else
nmosmw_4n ( d s ) resistor r=1e30
notvalid paramtest errorif=(modnm==0) \
message="
***************************************************
*
* nmosm is not valid in selected process option.
*
***************************************************"
model mosinsub bsim3v3 version=3.2400e+00  type=n  capmod=3.0000e+00 \
 mobmod=1.0000e+00  nqsmod=0.0000e+00  noimod=3.0000e+00 \
   vbox=1.000e+03      k1=8.4760e-01 \
     k2=0.0000e+00      k3=-2.500e+00     k3b=-5.640e-02 \
    nch=1.3360e+17 vth0=6.1630e-01+dvthmat \
   voff=-9.684e-02    dvt0=2.0510e+01    dvt1=1.0610e+00 \
   dvt2=2.5970e-02    keta=3.2000e-02 \
 pscbe1=1.0000e+30  pscbe2=1.0000e-06 \
 alpha0=5.5350e-08  alpha1=1.3930e-01   beta0=1.9570e+01 \
  dvt0w=1.0800e+01   dvt1w=3.0990e+06   dvt2w=1.4520e-01 \
     ua=4.5710e-10      ub=1.7380e-18      uc=5.7540e-11 \
u0=5.7350e+02+(5.7350e+02)*dumat \
   dsub=5.0000e-01    eta0=4.0860e-02    etab=-1.000e-03 \
nfactor=8.6050e-01 \
     em=4.1000e+07    pclm=9.0000e-01 \
  drout=5.0000e-01 \
     a0=1.0000e+00      a1=0.0000e+00      a2=1.0000e+00 \
   pvag=6.0000e-02    vsat=6.3000e+04     ags=1.4990e-01      b0=2.0000e-08      b1=1.0000e-08 \
  delta=1.0000e-02 pdiblcb=9.7980e-01 \
pdiblc1=3.2000e-02 pdiblc2=1.6680e-03 \
     w0=3.3160e-08 \
    dlc=1.3960e-09 \
dwc=-2.884e-01*l+1.4740e-07    dwb=8.6800e-09     dwg=-3.770e-09 \
     ll=6.7850e-14      lw=0.0000e+00     lwl=0.0000e+00 \
    lln=1.0000e+00     lwn=1.0000e+00      wl=-1.989e-13 \
     ww=-1.514e-14     wwl=-1.321e-20     wln=1.0000e+00 \
     wr=1.0000e+00     wwn=1.0000e+00 \
     at=3.3000e+04     ute=-1.720e+00 \
    kt1=-4.180e-01     kt2=-4.560e-02    kt1l=0.0000e+00 \
    ua1=0.0000e+00     ub1=0.0000e+00     uc1=0.0000e+00 \
    prt=0.0000e+00 \
   cgso=1.0050e-10    cgdo=1.0050e-10    cgbo=1.6000e-08 \
   cgdl=9.2000e-11    cgsl=9.2000e-11  ckappa=2.9570e+00 \
     cf=0.0000e+00     elm=5.0000e+00 \
  xpart=1.0000e+00     clc=1.0000e-15     cle=6.0000e-01 \
\
   rdsw=2.7670e+03 \
   cdsc=0.0000e+00   cdscb=2.0000e-03   cdscd=0.0000e+00 \
   prwb=2.0000e-02    prwg=1.0000e-02     cit=0.0000e+00 \
tox=1.5000e-08 \
  ngate=1.0000e+00 \
    nlx=1.5690e-07 \
     xl=-5.010e-08      xw=0.0000e+00 \
     af=1.3580e+00      kf=3.4460e-26      ef=1.0000e+00 \
   noia=1.7020e+20    noib=5.4630e+05    noic=-1.400e-11 \
     rd=0.0000e+00      rs=0.0000e+00     rsh=6.8470e+01 \
   minr=1.000e-03 \
    rdc=0.0000e+00     rsc=0.0000e+00 lint=-2.104e-07 \
wint=-7.006e-07   ldif=0.000e+00    hdif=6.0000e-07 \
     xj=3.0000e-07      js=5.1000e-07 \
      n=1.0000e+00 \
  dskip=no          tlev=0           tlevc=0         \
    jsw=6.0000e-13 \
     cj=6.2250e-04    cjsw=1.8750e-10 \
     fc=0.0000e+00    fcsw=0.000e+00 \
     mj=3.4000e-01    mjsw=2.3000e-01 \
     pb=6.9000e-01    pbsw=6.9000e-01     xti=2.0300e+00
ends nmosmw_4n

// ----------------------------------------------------------------------

// ----------------------------------------------------------------------
// Owner: austriamicrosystems
// HIT-Kit: Digital
// ************************ SIMULATION PARAMETERS ************************
//  ----------------------------------------------------------------------
//  format    : Spectre (Spectre Direct)
//  model     : MOS BSIM3v3
//  process   : C35
//  revision  : 1.0;
//  extracted : C18069; 28.08.2011; bse (5866)
//  doc#      : Eng-?? REV_0
//  ----------------------------------------------------------------------
//                         WORST CASE ONE CONDITION
//
//  ----------------------------------------------------------------------
//
inline subckt pmosw_2n ( d g s b )
parameters w=1.0e-6 l=1.0e-6 nrd=0.0 nrs=0.0 ad=0.0 as=0.0 pd=0.0 ps=0.0 ng=1
+ ws= w
+ ls= l
+ shk=1
+ dvthmat=(mv_pmosw_2n)*(1.03e-08/sqrt(ls*ws*ng)) dumat=(mu_pmosw_2n)*(4.89e-9/sqrt(ls*ws*ng))
//
if (modp==1)
pmosw_2n ( d g s b ) mosinsub w=ws l=ls nrd=8.0000e-07/ws nrs=8.0000e-07/ws ad=ad as=as pd=pd ps=ps m=ng
else
pmosw_2n ( d s ) resistor r=1e30
notvalid paramtest errorif=(modp==0) \
message="
***************************************************
*
* pmos is not valid in selected process option.
*
***************************************************"
model mosinsub bsim3v3 version=3.2400e+00  type=p  capmod=3.0000e+00 \
 mobmod=1.0000e+00  nqsmod=0.0000e+00  noimod=3.0000e+00 \
   vbox=1.000e+03      k1=2.4220e-01 \
     k2=0.0000e+00      k3=5.2000e+00     k3b=-1.000e+00 \
    nch=1.0480e+17 vth0=-8.534e-01+dvthmat \
   voff=-1.640e-01    dvt0=2.2000e+00    dvt1=6.3470e-01 \
   dvt2=5.3690e-02    keta=-7.600e-03 \
 pscbe1=1.0000e+30  pscbe2=1.0000e-06 \
 alpha0=1.0000e-09  alpha1=1.1750e-02   beta0=2.2870e+01 \
  dvt0w=1.0090e-01   dvt1w=7.3400e+04   dvt2w=-6.310e-03 \
     ua=4.1690e-10      ub=1.9050e-18      uc=-3.631e-11 \
u0=1.5460e+02+(1.5460e+02)*dumat \
   dsub=5.0000e-01    eta0=2.4000e-01    etab=-3.917e-03 \
nfactor=1.0000e+00 \
     em=4.1000e+07    pclm=3.3380e+00 \
  drout=5.0000e-01 \
     a0=9.0000e-01      a1=1.4440e-15      a2=5.0780e-01 \
   pvag=1.0000e-03    vsat=6.0900e+04     ags=2.1480e-01      b0=2.1920e-07      b1=0.0000e+00 \
  delta=1.0000e-02 pdiblcb=1.0000e-02 \
pdiblc1=8.9340e+02 pdiblc2=1.8000e-03 \
     w0=-1.500e-07 \
    dlc=-2.929e-08 \
dwc=-3.000e-01*l+1.5000e-07    dwb=-5.244e-09     dwg=-1.100e-08 \
     ll=3.5530e-15      lw=0.0000e+00     lwl=0.0000e+00 \
    lln=1.0000e+00     lwn=1.0000e+00      wl=-1.712e-12 \
     ww=-4.300e-14     wwl=-2.884e-21     wln=1.0000e+00 \
     wr=1.0000e+00     wwn=1.0000e+00 \
     at=3.3000e+04     ute=-1.300e+00 \
    kt1=-4.740e-01     kt2=-5.440e-02    kt1l=-1.600e-08 \
    ua1=0.0000e+00     ub1=-3.802e-19     uc1=0.0000e+00 \
    prt=0.0000e+00 \
   cgso=9.0000e-11    cgdo=9.0000e-11    cgbo=1.7000e-08 \
   cgdl=1.4637e-10    cgsl=1.4637e-10  ckappa=1.0000e-01 \
     cf=0.0000e+00     elm=5.0000e+00 \
  xpart=1.0000e+00     clc=1.0000e-15     cle=6.0000e-01 \
\
   rdsw=1.0660e+04 \
   cdsc=1.2000e-02   cdscb=9.0000e-03   cdscd=1.0000e-03 \
   prwb=1.9620e-02    prwg=-3.558e-02     cit=0.0000e+00 \
tox=7.7540e-09 \
  ngate=0.0000e+00 \
    nlx=3.0770e-08 \
     xl=2.4000e-07      xw=0.0000e+00 \
     af=1.4050e+00      kf=1.8270e-26      ef=1.0000e+00 \
   noia=7.0910e+18    noib=6.0740e+04    noic=3.7790e-13 \
     rd=0.0000e+00      rs=0.0000e+00     rsh=1.5200e+02 \
   minr=1.000e-03 \
    rdc=0.0000e+00     rsc=0.0000e+00 lint=-7.965e-07 \
wint=-1.959e-06   ldif=0.000e+00    hdif=8.0000e-07 \
     xj=3.0000e-07      js=2.8000e-07 \
      n=1.0000e+00 \
  dskip=no          tlev=0           tlevc=0         \
    jsw=3.7000e-13 \
     cj=1.7000e-03    cjsw=4.3750e-10 \
     fc=0.0000e+00    fcsw=0.000e+00 \
     mj=5.4000e-01    mjsw=4.6000e-01 \
     pb=1.0200e+00    pbsw=1.0200e+00     xti=1.9730e+00
ends pmosw_2n

// ----------------------------------------------------------------------

// ----------------------------------------------------------------------
// Owner: austriamicrosystems
// HIT-Kit: Digital
// ************************ SIMULATION PARAMETERS ************************
//  ----------------------------------------------------------------------
//  format    : Spectre (Spectre Direct)
//  model     : MOS BSIM3v3
//  process   : C35
//  revision  : 1.0;
//  extracted : C18069; 28.08.2011; bse (5866)
//  doc#      : Eng-?? REV_0
//  ----------------------------------------------------------------------
//                         WORST CASE ONE CONDITION
//
//  ----------------------------------------------------------------------
//
inline subckt pmosw_3n ( d g s b )
parameters w=1.0e-6 l=1.0e-6 nrd=0.0 nrs=0.0 ad=0.0 as=0.0 pd=0.0 ps=0.0 ng=1
+ ws= w
+ ls= l
+ shk=1
+ dvthmat=(mv_pmosw_3n)*(1.03e-08/sqrt(ls*ws*ng)) dumat=(mu_pmosw_3n)*(4.89e-9/sqrt(ls*ws*ng))
//
if (modp==1)
pmosw_3n ( d g s b ) mosinsub w=ws l=ls nrd=8.0000e-07/ws nrs=8.0000e-07/ws ad=ad as=as pd=pd ps=ps m=ng
else
pmosw_3n ( d s ) resistor r=1e30
notvalid paramtest errorif=(modp==0) \
message="
***************************************************
*
* pmos is not valid in selected process option.
*
***************************************************"
model mosinsub bsim3v3 version=3.2400e+00  type=p  capmod=3.0000e+00 \
 mobmod=1.0000e+00  nqsmod=0.0000e+00  noimod=3.0000e+00 \
   vbox=1.000e+03      k1=2.4220e-01 \
     k2=0.0000e+00      k3=5.2000e+00     k3b=-1.000e+00 \
    nch=1.0480e+17 vth0=-8.534e-01+dvthmat \
   voff=-1.640e-01    dvt0=2.2000e+00    dvt1=6.3470e-01 \
   dvt2=5.3690e-02    keta=-7.600e-03 \
 pscbe1=1.0000e+30  pscbe2=1.0000e-06 \
 alpha0=1.0000e-09  alpha1=1.1750e-02   beta0=2.2870e+01 \
  dvt0w=1.0090e-01   dvt1w=7.3400e+04   dvt2w=-6.310e-03 \
     ua=4.1690e-10      ub=1.9050e-18      uc=-3.631e-11 \
u0=1.5460e+02+(1.5460e+02)*dumat \
   dsub=5.0000e-01    eta0=2.4000e-01    etab=-3.917e-03 \
nfactor=1.0000e+00 \
     em=4.1000e+07    pclm=3.5650e+00 \
  drout=5.0000e-01 \
     a0=9.0000e-01      a1=1.4440e-15      a2=5.0780e-01 \
   pvag=4.6400e+00    vsat=1.0000e+05     ags=3.8020e-01      b0=2.1920e-07      b1=0.0000e+00 \
  delta=1.0000e-02 pdiblcb=1.0000e+00 \
pdiblc1=8.3320e+00 pdiblc2=2.0670e-03 \
     w0=-1.500e-07 \
    dlc=-2.929e-08 \
dwc=-3.000e-01*l+1.5000e-07    dwb=-5.244e-09     dwg=-1.100e-08 \
     ll=3.5530e-15      lw=0.0000e+00     lwl=0.0000e+00 \
    lln=1.0000e+00     lwn=1.0000e+00      wl=-5.064e-13 \
     ww=-4.300e-14     wwl=-2.884e-21     wln=1.0000e+00 \
     wr=1.0000e+00     wwn=1.0000e+00 \
     at=3.3000e+04     ute=-1.300e+00 \
    kt1=-4.740e-01     kt2=-5.440e-02    kt1l=-1.600e-08 \
    ua1=0.0000e+00     ub1=-3.802e-19     uc1=0.0000e+00 \
    prt=0.0000e+00 \
   cgso=9.0000e-11    cgdo=9.0000e-11    cgbo=1.7000e-08 \
   cgdl=1.4637e-10    cgsl=1.4637e-10  ckappa=1.0000e-01 \
     cf=0.0000e+00     elm=5.0000e+00 \
  xpart=1.0000e+00     clc=1.0000e-15     cle=6.0000e-01 \
\
   rdsw=5.7750e+03 \
   cdsc=1.2000e-02   cdscb=9.0000e-03   cdscd=1.0000e-03 \
   prwb=1.9620e-02    prwg=-1.019e-02     cit=0.0000e+00 \
tox=7.7540e-09 \
  ngate=0.0000e+00 \
    nlx=3.0770e-08 \
     xl=1.4590e-07      xw=0.0000e+00 \
     af=1.4050e+00      kf=1.8270e-26      ef=1.0000e+00 \
   noia=7.0910e+18    noib=6.0740e+04    noic=3.7790e-13 \
     rd=0.0000e+00      rs=0.0000e+00     rsh=1.5200e+02 \
   minr=1.000e-03 \
    rdc=0.0000e+00     rsc=0.0000e+00 lint=-3.275e-07 \
wint=-9.593e-07   ldif=0.000e+00    hdif=8.0000e-07 \
     xj=3.0000e-07      js=2.8000e-07 \
      n=1.0000e+00 \
  dskip=no          tlev=0           tlevc=0         \
    jsw=3.7000e-13 \
     cj=1.7000e-03    cjsw=4.3750e-10 \
     fc=0.0000e+00    fcsw=0.000e+00 \
     mj=5.4000e-01    mjsw=4.6000e-01 \
     pb=1.0200e+00    pbsw=1.0200e+00     xti=1.9730e+00
ends pmosw_3n

// ----------------------------------------------------------------------

// ----------------------------------------------------------------------
// Owner: austriamicrosystems
// HIT-Kit: Digital
// ************************ SIMULATION PARAMETERS ************************
//  ----------------------------------------------------------------------
//  format    : Spectre (Spectre Direct)
//  model     : MOS BSIM3v3
//  process   : C35
//  revision  : 1.0;
//  extracted : C18069; 28.08.2011; bse (5866)
//  doc#      : Eng-?? REV_0
//  ----------------------------------------------------------------------
//                         WORST CASE ONE CONDITION
//
//  ----------------------------------------------------------------------
//
inline subckt pmosw_4n ( d g s b )
parameters w=1.0e-6 l=1.0e-6 nrd=0.0 nrs=0.0 ad=0.0 as=0.0 pd=0.0 ps=0.0 ng=1
+ ws= w
+ ls= l
+ shk=1
+ dvthmat=(mv_pmosw_4n)*(1.03e-08/sqrt(ls*ws*ng)) dumat=(mu_pmosw_4n)*(4.89e-9/sqrt(ls*ws*ng))
//
if (modp==1)
pmosw_4n ( d g s b ) mosinsub w=ws l=ls nrd=8.0000e-07/ws nrs=8.0000e-07/ws ad=ad as=as pd=pd ps=ps m=ng
else
pmosw_4n ( d s ) resistor r=1e30
notvalid paramtest errorif=(modp==0) \
message="
***************************************************
*
* pmos is not valid in selected process option.
*
***************************************************"
model mosinsub bsim3v3 version=3.2400e+00  type=p  capmod=3.0000e+00 \
 mobmod=1.0000e+00  nqsmod=0.0000e+00  noimod=3.0000e+00 \
   vbox=1.000e+03      k1=2.4220e-01 \
     k2=0.0000e+00      k3=5.2000e+00     k3b=-1.000e+00 \
    nch=1.0480e+17 vth0=-8.534e-01+dvthmat \
   voff=-1.640e-01    dvt0=2.2000e+00    dvt1=6.3470e-01 \
   dvt2=5.3690e-02    keta=-7.600e-03 \
 pscbe1=1.0000e+30  pscbe2=1.0000e-06 \
 alpha0=1.0000e-09  alpha1=1.1750e-02   beta0=2.2870e+01 \
  dvt0w=1.0090e-01   dvt1w=7.3400e+04   dvt2w=-6.310e-03 \
     ua=4.1690e-10      ub=1.9050e-18      uc=-3.631e-11 \
u0=1.5460e+02+(1.5460e+02)*dumat \
   dsub=5.0000e-01    eta0=2.4000e-01    etab=-3.917e-03 \
nfactor=1.0000e+00 \
     em=4.1000e+07    pclm=3.5650e+00 \
  drout=5.0000e-01 \
     a0=9.0000e-01      a1=1.4440e-15      a2=5.0780e-01 \
   pvag=4.6400e+00    vsat=1.5480e+05     ags=3.8020e-01      b0=2.1920e-07      b1=0.0000e+00 \
  delta=1.0000e-02 pdiblcb=1.0000e+00 \
pdiblc1=5.6700e+00 pdiblc2=3.0670e-03 \
     w0=-1.500e-07 \
    dlc=-2.929e-08 \
dwc=-3.000e-01*l+1.5000e-07    dwb=-5.244e-09     dwg=-1.100e-08 \
     ll=3.5530e-15      lw=0.0000e+00     lwl=0.0000e+00 \
    lln=1.0000e+00     lwn=1.0000e+00      wl=-5.064e-13 \
     ww=-4.300e-14     wwl=-2.884e-21     wln=1.0000e+00 \
     wr=1.0000e+00     wwn=1.0000e+00 \
     at=3.3000e+04     ute=-1.300e+00 \
    kt1=-4.740e-01     kt2=-5.440e-02    kt1l=-1.600e-08 \
    ua1=0.0000e+00     ub1=-3.802e-19     uc1=0.0000e+00 \
    prt=0.0000e+00 \
   cgso=9.0000e-11    cgdo=9.0000e-11    cgbo=1.7000e-08 \
   cgdl=1.4637e-10    cgsl=1.4637e-10  ckappa=1.0000e-01 \
     cf=0.0000e+00     elm=5.0000e+00 \
  xpart=1.0000e+00     clc=1.0000e-15     cle=6.0000e-01 \
\
   rdsw=5.7750e+03 \
   cdsc=1.2000e-02   cdscb=9.0000e-03   cdscd=1.0000e-03 \
   prwb=1.9620e-02    prwg=-7.244e-03     cit=0.0000e+00 \
tox=7.7540e-09 \
  ngate=0.0000e+00 \
    nlx=3.0770e-08 \
     xl=1.5200e-07      xw=0.0000e+00 \
     af=1.4050e+00      kf=1.8270e-26      ef=1.0000e+00 \
   noia=7.0910e+18    noib=6.0740e+04    noic=3.7790e-13 \
     rd=0.0000e+00      rs=0.0000e+00     rsh=1.5200e+02 \
   minr=1.000e-03 \
    rdc=0.0000e+00     rsc=0.0000e+00 lint=-2.996e-07 \
wint=-6.844e-07   ldif=0.000e+00    hdif=8.0000e-07 \
     xj=3.0000e-07      js=2.8000e-07 \
      n=1.0000e+00 \
  dskip=no          tlev=0           tlevc=0         \
    jsw=3.7000e-13 \
     cj=1.7000e-03    cjsw=4.3750e-10 \
     fc=0.0000e+00    fcsw=0.000e+00 \
     mj=5.4000e-01    mjsw=4.6000e-01 \
     pb=1.0200e+00    pbsw=1.0200e+00     xti=1.9730e+00
ends pmosw_4n

// ----------------------------------------------------------------------

// ----------------------------------------------------------------------
// Owner: austriamicrosystems
// HIT-Kit: Digital
// ************************ SIMULATION PARAMETERS ************************
//  ----------------------------------------------------------------------
//  format    : Spectre (Spectre Direct)
//  model     : MOS BSIM3v3
//  process   : C35
//  revision  : 1.0;
//  extracted : C18069; 28.08.2011; bse (5866)
//  doc#      : Eng-?? REV_0
//  ----------------------------------------------------------------------
//                         WORST CASE ONE CONDITION
//
//  ----------------------------------------------------------------------
//
inline subckt pmosmw_2n ( d g s b )
parameters w=1.0e-6 l=1.0e-6 nrd=0.0 nrs=0.0 ad=0.0 as=0.0 pd=0.0 ps=0.0 ng=1
+ ws= w
+ ls= l
+ shk=1
+ dvthmat=(mv_pmosmw_2n)*(1.5e-08/sqrt(ls*ws*ng)) dumat=(mu_pmosmw_2n)*(4.3e-9/sqrt(ls*ws*ng))
//
if (modpm==1)
pmosmw_2n ( d g s b ) mosinsub w=ws l=ls nrd=6.0000e-07/ws nrs=6.0000e-07/ws ad=ad as=as pd=pd ps=ps m=ng
else
pmosmw_2n ( d s ) resistor r=1e30
notvalid paramtest errorif=(modpm==0) \
message="
***************************************************
*
* pmosm is not valid in selected process option.
*
***************************************************"
model mosinsub bsim3v3 version=3.2400e+00  type=p  capmod=3.0000e+00 \
 mobmod=1.0000e+00  nqsmod=0.0000e+00  noimod=3.0000e+00 \
   vbox=1.000e+03      k1=4.4140e-01 \
     k2=0.0000e+00      k3=1.8000e+00     k3b=-1.000e+00 \
    nch=9.2600e+16 vth0=-1.186e+00+dvthmat \
   voff=-1.148e-01    dvt0=1.7000e+00    dvt1=4.0100e-01 \
   dvt2=2.0050e-01    keta=2.0800e-02 \
 pscbe1=1.0000e+30  pscbe2=1.0000e-06 \
 alpha0=1.0000e-07  alpha1=3.1620e+00   beta0=4.2260e+01 \
  dvt0w=2.0000e-01   dvt1w=5.0000e+05   dvt2w=-3.200e+00 \
     ua=3.1000e-09      ub=2.2000e-19      uc=-8.318e-11 \
u0=1.9990e+02+(1.9990e+02)*dumat \
   dsub=5.0000e-01    eta0=1.7900e-03    etab=-2.948e-02 \
nfactor=7.0460e-01 \
     em=4.1000e+07    pclm=4.9580e+00 \
  drout=5.0000e-01 \
     a0=1.0000e+00      a1=6.0520e-05      a2=2.2110e-01 \
   pvag=1.0000e+00    vsat=5.0470e+04     ags=1.4450e-01      b0=1.3800e-07      b1=0.0000e+00 \
  delta=1.0000e-02 pdiblcb=6.0000e-02 \
pdiblc1=2.5900e+04 pdiblc2=2.4430e-03 \
     w0=-1.800e-07 \
    dlc=-1.766e-08 \
dwc=-2.953e-01*l+1.4210e-07    dwb=-4.580e-09     dwg=-6.295e-09 \
     ll=0.0000e+00      lw=0.0000e+00     lwl=0.0000e+00 \
    lln=1.0000e+00     lwn=1.0000e+00      wl=-3.685e-12 \
     ww=-3.900e-14     wwl=-4.467e-21     wln=1.0000e+00 \
     wr=1.0000e+00     wwn=1.0000e+00 \
     at=7.9640e+04     ute=-1.492e+00 \
    kt1=-5.480e-01     kt2=-6.000e-02    kt1l=-2.600e-08 \
    ua1=-2.630e-10     ub1=-3.311e-18     uc1=0.0000e+00 \
    prt=0.0000e+00 \
   cgso=1.0010e-10    cgdo=1.0010e-10    cgbo=8.0000e-09 \
   cgdl=1.1630e-10    cgsl=1.1630e-10  ckappa=1.3700e+00 \
     cf=0.0000e+00     elm=5.0000e+00 \
  xpart=1.0000e+00     clc=1.0000e-15     cle=6.0000e-01 \
\
   rdsw=1.0820e+04 \
   cdsc=1.2140e-03   cdscb=2.9450e-04   cdscd=0.0000e+00 \
   prwb=5.0700e-02    prwg=7.0360e-02     cit=5.2590e-05 \
tox=1.5000e-08 \
  ngate=0.0000e+00 \
    nlx=1.2500e-07 \
     xl=3.8000e-07      xw=0.0000e+00 \
     af=1.5640e+00      kf=4.8520e-26      ef=1.0000e+00 \
   noia=1.8720e+18    noib=3.4540e+04    noic=1.2460e-12 \
     rd=0.0000e+00      rs=0.0000e+00     rsh=1.5320e+02 \
   minr=1.000e-03 \
    rdc=0.0000e+00     rsc=0.0000e+00 lint=-1.646e-06 \
wint=-2.751e-06   ldif=0.000e+00    hdif=6.0000e-07 \
     xj=3.0000e-07      js=2.8000e-07 \
      n=1.0000e+00 \
  dskip=no          tlev=0           tlevc=0         \
    jsw=3.7000e-13 \
     cj=1.7000e-03    cjsw=4.3750e-10 \
     fc=0.0000e+00    fcsw=0.000e+00 \
     mj=5.4000e-01    mjsw=4.6000e-01 \
     pb=1.0200e+00    pbsw=1.0200e+00     xti=1.9700e+00
ends pmosmw_2n

// ----------------------------------------------------------------------

// ----------------------------------------------------------------------
// Owner: austriamicrosystems
// HIT-Kit: Digital
// ************************ SIMULATION PARAMETERS ************************
//  ----------------------------------------------------------------------
//  format    : Spectre (Spectre Direct)
//  model     : MOS BSIM3v3
//  process   : C35
//  revision  : 1.0;
//  extracted : C18069; 28.08.2011; bse (5866)
//  doc#      : Eng-?? REV_0
//  ----------------------------------------------------------------------
//                         WORST CASE ONE CONDITION
//
//  ----------------------------------------------------------------------
//
inline subckt pmosmw_3n ( d g s b )
parameters w=1.0e-6 l=1.0e-6 nrd=0.0 nrs=0.0 ad=0.0 as=0.0 pd=0.0 ps=0.0 ng=1
+ ws= w
+ ls= l
+ shk=1
+ dvthmat=(mv_pmosmw_3n)*(1.5e-08/sqrt(ls*ws*ng)) dumat=(mu_pmosmw_3n)*(4.3e-9/sqrt(ls*ws*ng))
//
if (modpm==1)
pmosmw_3n ( d g s b ) mosinsub w=ws l=ls nrd=6.0000e-07/ws nrs=6.0000e-07/ws ad=ad as=as pd=pd ps=ps m=ng
else
pmosmw_3n ( d s ) resistor r=1e30
notvalid paramtest errorif=(modpm==0) \
message="
***************************************************
*
* pmosm is not valid in selected process option.
*
***************************************************"
model mosinsub bsim3v3 version=3.2400e+00  type=p  capmod=3.0000e+00 \
 mobmod=1.0000e+00  nqsmod=0.0000e+00  noimod=3.0000e+00 \
   vbox=1.000e+03      k1=4.4140e-01 \
     k2=0.0000e+00      k3=1.8000e+00     k3b=-1.000e+00 \
    nch=9.2600e+16 vth0=-1.186e+00+dvthmat \
   voff=-1.148e-01    dvt0=1.7000e+00    dvt1=4.0100e-01 \
   dvt2=2.0050e-01    keta=2.0800e-02 \
 pscbe1=1.0000e+30  pscbe2=1.0000e-06 \
 alpha0=1.0000e-07  alpha1=3.1620e+00   beta0=4.2260e+01 \
  dvt0w=2.0000e-01   dvt1w=5.0000e+05   dvt2w=-3.200e+00 \
     ua=3.1000e-09      ub=2.2000e-19      uc=-1.553e-10 \
u0=1.9990e+02+(1.9990e+02)*dumat \
   dsub=5.0000e-01    eta0=1.7900e-03    etab=-2.948e-02 \
nfactor=7.0460e-01 \
     em=4.1000e+07    pclm=4.9580e+00 \
  drout=5.0000e-01 \
     a0=1.0000e+00      a1=6.0520e-05      a2=2.2110e-01 \
   pvag=-1.500e+00    vsat=4.9050e+04     ags=1.4450e-01      b0=1.3800e-07      b1=0.0000e+00 \
  delta=1.0000e-02 pdiblcb=6.0000e-02 \
pdiblc1=2.6560e+02 pdiblc2=2.6870e-03 \
     w0=-1.800e-07 \
    dlc=-1.766e-08 \
dwc=-2.953e-01*l+1.4210e-07    dwb=-4.580e-09     dwg=-6.295e-09 \
     ll=0.0000e+00      lw=0.0000e+00     lwl=0.0000e+00 \
    lln=1.0000e+00     lwn=1.0000e+00      wl=-2.315e-12 \
     ww=-3.900e-14     wwl=-4.467e-21     wln=1.0000e+00 \
     wr=1.0000e+00     wwn=1.0000e+00 \
     at=7.9640e+04     ute=-1.492e+00 \
    kt1=-5.480e-01     kt2=-6.000e-02    kt1l=-2.600e-08 \
    ua1=-2.630e-10     ub1=-3.311e-18     uc1=0.0000e+00 \
    prt=0.0000e+00 \
   cgso=1.0010e-10    cgdo=1.0010e-10    cgbo=8.0000e-09 \
   cgdl=1.1630e-10    cgsl=1.1630e-10  ckappa=1.3700e+00 \
     cf=0.0000e+00     elm=5.0000e+00 \
  xpart=1.0000e+00     clc=1.0000e-15     cle=6.0000e-01 \
\
   rdsw=1.1340e+04 \
   cdsc=1.2140e-03   cdscb=2.9450e-04   cdscd=0.0000e+00 \
   prwb=-5.503e-02    prwg=1.5470e-02     cit=5.2590e-05 \
tox=1.5000e-08 \
  ngate=0.0000e+00 \
    nlx=1.2500e-07 \
     xl=3.2000e-07      xw=0.0000e+00 \
     af=1.5640e+00      kf=4.8520e-26      ef=1.0000e+00 \
   noia=1.8720e+18    noib=3.4540e+04    noic=1.2460e-12 \
     rd=0.0000e+00      rs=0.0000e+00     rsh=1.5320e+02 \
   minr=1.000e-03 \
    rdc=0.0000e+00     rsc=0.0000e+00 lint=-1.020e-06 \
wint=-1.770e-06   ldif=0.000e+00    hdif=6.0000e-07 \
     xj=3.0000e-07      js=2.8000e-07 \
      n=1.0000e+00 \
  dskip=no          tlev=0           tlevc=0         \
    jsw=3.7000e-13 \
     cj=1.7000e-03    cjsw=4.3750e-10 \
     fc=0.0000e+00    fcsw=0.000e+00 \
     mj=5.4000e-01    mjsw=4.6000e-01 \
     pb=1.0200e+00    pbsw=1.0200e+00     xti=1.9700e+00
ends pmosmw_3n

// ----------------------------------------------------------------------

// ----------------------------------------------------------------------
// Owner: austriamicrosystems
// HIT-Kit: Digital
// ************************ SIMULATION PARAMETERS ************************
//  ----------------------------------------------------------------------
//  format    : Spectre (Spectre Direct)
//  model     : MOS BSIM3v3
//  process   : C35
//  revision  : 1.0;
//  extracted : C18069; 28.08.2011; bse (5866)
//  doc#      : Eng-?? REV_0
//  ----------------------------------------------------------------------
//                         WORST CASE ONE CONDITION
//
//  ----------------------------------------------------------------------
//
inline subckt pmosmw_4n ( d g s b )
parameters w=1.0e-6 l=1.0e-6 nrd=0.0 nrs=0.0 ad=0.0 as=0.0 pd=0.0 ps=0.0 ng=1
+ ws= w
+ ls= l
+ shk=1
+ dvthmat=(mv_pmosmw_4n)*(1.5e-08/sqrt(ls*ws*ng)) dumat=(mu_pmosmw_4n)*(4.3e-9/sqrt(ls*ws*ng))
//
if (modpm==1)
pmosmw_4n ( d g s b ) mosinsub w=ws l=ls nrd=6.0000e-07/ws nrs=6.0000e-07/ws ad=ad as=as pd=pd ps=ps m=ng
else
pmosmw_4n ( d s ) resistor r=1e30
notvalid paramtest errorif=(modpm==0) \
message="
***************************************************
*
* pmosm is not valid in selected process option.
*
***************************************************"
model mosinsub bsim3v3 version=3.2400e+00  type=p  capmod=3.0000e+00 \
 mobmod=1.0000e+00  nqsmod=0.0000e+00  noimod=3.0000e+00 \
   vbox=1.000e+03      k1=4.4140e-01 \
     k2=0.0000e+00      k3=1.8000e+00     k3b=-1.000e+00 \
    nch=9.2600e+16 vth0=-1.186e+00+dvthmat \
   voff=-1.148e-01    dvt0=1.7000e+00    dvt1=4.0100e-01 \
   dvt2=2.0050e-01    keta=2.0800e-02 \
 pscbe1=1.0000e+30  pscbe2=1.0000e-06 \
 alpha0=1.0000e-07  alpha1=3.1620e+00   beta0=4.2260e+01 \
  dvt0w=2.0000e-01   dvt1w=5.0000e+05   dvt2w=-3.200e+00 \
     ua=3.1000e-09      ub=2.2000e-19      uc=-8.318e-11 \
u0=1.9990e+02+(1.9990e+02)*dumat \
   dsub=5.0000e-01    eta0=1.7900e-03    etab=-2.948e-02 \
nfactor=7.0460e-01 \
     em=4.1000e+07    pclm=4.9580e+00 \
  drout=5.0000e-01 \
     a0=1.0000e+00      a1=6.0520e-05      a2=2.2110e-01 \
   pvag=-1.500e+00    vsat=6.7470e+04     ags=1.4450e-01      b0=1.3800e-07      b1=0.0000e+00 \
  delta=1.0000e-02 pdiblcb=6.0000e-02 \
pdiblc1=2.8350e+01 pdiblc2=3.8950e-03 \
     w0=-1.800e-07 \
    dlc=-1.766e-08 \
dwc=-2.953e-01*l+1.4210e-07    dwb=-4.580e-09     dwg=-6.295e-09 \
     ll=0.0000e+00      lw=0.0000e+00     lwl=0.0000e+00 \
    lln=1.0000e+00     lwn=1.0000e+00      wl=-1.534e-12 \
     ww=-3.900e-14     wwl=-4.467e-21     wln=1.0000e+00 \
     wr=1.0000e+00     wwn=1.0000e+00 \
     at=7.9640e+04     ute=-1.492e+00 \
    kt1=-5.480e-01     kt2=-6.000e-02    kt1l=-2.600e-08 \
    ua1=-2.630e-10     ub1=-3.311e-18     uc1=0.0000e+00 \
    prt=0.0000e+00 \
   cgso=1.0010e-10    cgdo=1.0010e-10    cgbo=8.0000e-09 \
   cgdl=1.1630e-10    cgsl=1.1630e-10  ckappa=1.3700e+00 \
     cf=0.0000e+00     elm=5.0000e+00 \
  xpart=1.0000e+00     clc=1.0000e-15     cle=6.0000e-01 \
\
   rdsw=6.6990e+03 \
   cdsc=1.2140e-03   cdscb=2.9450e-04   cdscd=0.0000e+00 \
   prwb=5.0700e-02    prwg=7.7360e-02     cit=5.2590e-05 \
tox=1.5000e-08 \
  ngate=0.0000e+00 \
    nlx=1.2500e-07 \
     xl=2.3990e-07      xw=0.0000e+00 \
     af=1.5640e+00      kf=4.8520e-26      ef=1.0000e+00 \
   noia=1.8720e+18    noib=3.4540e+04    noic=1.2460e-12 \
     rd=0.0000e+00      rs=0.0000e+00     rsh=1.5320e+02 \
   minr=1.000e-03 \
    rdc=0.0000e+00     rsc=0.0000e+00 lint=-7.278e-07 \
wint=-1.000e-06   ldif=0.000e+00    hdif=6.0000e-07 \
     xj=3.0000e-07      js=2.8000e-07 \
      n=1.0000e+00 \
  dskip=no          tlev=0           tlevc=0         \
    jsw=3.7000e-13 \
     cj=1.7000e-03    cjsw=4.3750e-10 \
     fc=0.0000e+00    fcsw=0.000e+00 \
     mj=5.4000e-01    mjsw=4.6000e-01 \
     pb=1.0200e+00    pbsw=1.0200e+00     xti=1.9700e+00
ends pmosmw_4n

// ----------------------------------------------------------------------

// ----------------------------------------------------------------------
// Owner: austriamicrosystems
// HIT-Kit: Digital
//************************ SIMULATION PARAMETERS ************************
// ----------------------------------------------------------------------
// format    : Spectre
// model     : MODNRF
// process   : CS ADFI
// revision  : 3.1;
// extracted : CSD C64330.04e3; 2002-09; kmo(5966)
// doc#      : ENG-188 REV_5
// ----------------------------------------------------------------------
//                        WORST CASE ONE CONDITION
// ----------------------------------------------------------------------
//
//  RF CMOS TRANSISTOR MODEL
//
//-----------------------------------------------------------------------
inline subckt modnrf ( d g s b )
parameters w=1.0e-6 l=1.0e-6 nrd=0.0 nrs=0.0 ad=0.0 as=0.0 pd=0.0 ps=0.0 ng=1
+ mmvth_modnrf=0.0 mmu0_modnrf=0.0
+ dvthmat=(mv_modnrf53+mmvth_modnrf)*(0.67e-08/sqrt(l*w*ng)) dumat=(mu_modnrf53+mmu0_modnrf)*(4.9e-9/sqrt(l*w*ng))
// //
if (modnrf==1){
// --------- Gate network ------------------------------
lg  (g 20 ) inductor l=1.000e-15
rg  (20 21 ) resistor r=((6.895e-04/w+4.758e+01 )/ng+(3.726e+05*w+2.740e+00)) isnoisy=yes
//
// --------- Drain network -----------------------------
ldrain ( d 13 ) inductor l=1.000e-15
rdrain ( 13 11 ) resistor r=(3.320e-04/(w*ng)+1.669e-01) isnoisy=yes
//
// --------- Source network -----------------------------
lsource ( s 33 ) inductor l=1.000e-15
rsource ( 33 31 ) resistor r=(3.320e-04/(w*ng)+1.669e-01) isnoisy=yes
//
// --------- Substrate network -------------------------
// Diodes are for n-type or p-type MOS transistors
//
djdb  ( 12 11 ) bulk_diode area=ad*ng perim=pd*ng
djsb  ( 32 31 ) bulk_diode area=as*ng perim=ps*ng
//
rsub1 ( 12 b ) resistor r=((0.000e+00/w+0.000e+00)/ng+(9.524e+06*w+(4.156e+01))) isnoisy=yes
rsub2 ( 32 b ) resistor r=((0.000e+00/w+0.000e+00)/ng+(9.524e+06*w+(4.156e+01))) isnoisy=yes
//
// --------- Ideal mos transistor ----------------------
modnrf ( 11 21 31 b ) mosinsub l=l w=w*ng ad=0.0 as=0.0 pd=0.0 ps=0.0 nrd=0 nrs=0
}else
modnrf ( d s ) resistor r=1e30
notvalid paramtest errorif=(modnrf==0) \
message="
***************************************************
*
* nmosrf is not valid in selected process option.
*
***************************************************"
// Intrinsic MOS transistor
model mosinsub bsim3v3 version=3.1 type=n  capmod=2.0000e+00 \
 mobmod=1.0000e+00  nqsmod=0.0000e+00  noimod=3 \
   vbox=1.000e+03      k1=4.9952e-01 \
     k2=1.0307e-02      k3=-1.715e+00     k3b=6.3250e-01 \
    nch=1.8730e+17 vth0=3.3550e-01+dvthmat \
   voff=-5.719e-02    dvt0=2.2270e+01    dvt1=1.0510e+00 \
   dvt2=3.3930e-03    keta=-6.207e-04 \
 pscbe1=2.7560e+08  pscbe2=9.6450e-06 \
 alpha0=0.0000e+00   beta0=3.0000e+01 \
  dvt0w=0.0000e+00   dvt1w=0.0000e+00   dvt2w=0.0000e+00 \
     ua=1.0000e-12      ub=4.8510e-18      uc=5.7560e-11 \
u0=6.4220e+02+(6.4220e+02)*dumat \
   dsub=5.0000e-01    eta0=3.0850e-02    etab=-3.947e-02 \
nfactor=1.1190e-01 \
     em=4.1000e+07    pclm=1.5270e+00 \
  drout=5.0000e-01 \
     a0=2.2080e+00      a1=0.0000e+00      a2=1.0000e+00 \
   pvag=0.0000e+00    vsat=7.5800e+04     ags=2.4900e-01      b0=-1.765e-08      b1=0.0000e+00 \
  delta=1.0000e-02 pdiblcb=2.5830e-01 \
pdiblc1=1.0760e-01 pdiblc2=1.4530e-03 \
     w0=1.1840e-07 \
    dlc=6.6050e-08 \
    dwc=2.6760e-08     dwb=0.0000e+00     dwg=0.0000e+00 \
     ll=0.000e+00      lw=0.000e+00     lwl=0.000e+00 \
    lln=1.000e+00     lwn=1.000e+00      wl=0.0000e+00 \
     ww=0.0000e+00     wwl=0.0000e+00     wln=1.0000e+00 \
     wr=1.0000e+00     wwn=1.0000e+00 \
     at=3.3000e+04     ute=-1.800e+00 \
    kt1=-3.302e-01     kt2=2.2000e-02    kt1l=0.0000e+00 \
    ua1=0.0000e+00     ub1=0.0000e+00     uc1=0.0000e+00 \
    prt=0.0000e+00 \
   cgso=1.8730e-10    cgdo=1.8730e-10    cgbo=1.1000e-10 \
   cgdl=8.8133e-11    cgsl=8.8133e-11  ckappa=6.0000e-01 \
     cf=0.0000e+00     elm=5.0000e+00 \
  xpart=1.0000e+00     clc=1.0000e-15     cle=6.0000e-01 \
\
   rdsw=0.0000e+00 \
   cdsc=0.0000e+00   cdscb=0.0000e+00   cdscd=8.4480e-05 \
   prwb=0.0000e+00    prwg=0.0000e+00     cit=1.0000e-03 \
tox=7.5000e-09 \
  ngate=0.0000e+00 \
    nlx=1.9180e-07 \
     xl=-5.000e-08      xw=2.5000e-08 \
     af=1.3760e+00      kf=3.3960e-26      ef=1.0000e+00 \
   noia=1.3990e+20    noib=2.7070e+05    noic=-4.680e-12 \
     rd=0.0000e+00      rs=0.0000e+00     rsh=8.2000e+01 \
   minr=1.000e-03 \
    rdc=0.0000e+00     rsc=0.0000e+00 lint=8.2850e-09 \
wint=2.6760e-08   ldif=0.000e+00    hdif=6.0000e-07 \
     xj=3.0000e-07      js=5.1000e-07 \
      n=1.0000e+00 \
  dskip=no          tlev=0           tlevc=0         \
    jsw=0.0000e+00 \
     cj=0.0000e+00    cjsw=0.0000e+00 \
     fc=0.0000e+00    fcsw=0.000e+00 \
     mj=3.1000e-01    mjsw=1.9000e-01 \
     pb=6.9000e-01    pbsw=6.9000e-01
// Bulk Diode Model
model bulk_diode diode level=1 dskip=no \
     is=5.100e-07      isw=0.600e-12       n=1.0000000       ns=1.0000000   \
    cjo=1.580e-03       m=3.100e-01 \
    cjsw=0.000e+00       mjsw=2.011E-01 \
     fc=0.000e+00      tt=0.000e+00      vj=6.900e-01      vjsw=6.672E-01  \
     kf=0.000e+00      eg=1.11e+00     xti=2.026e+00      af=1.000e+00
ends modnrf
// ----------------------------------------------------------------------
// ----------------------------------------------------------------------
// Owner: austriamicrosystems
// HIT-Kit: Digital
//************************ SIMULATION PARAMETERS ************************
// ----------------------------------------------------------------------
// format    : Spectre
// model     : MODPRF
// process   : C/B/S 35
// revision  : 3.1;
// extracted : C35B3 B11634.L1 04PA3; 2002-09; kmo(5966)
// doc#      : ENG-188 REV_5
// ----------------------------------------------------------------------
//                        WORST CASE ONE CONDITION
// ----------------------------------------------------------------------
//
//  RF CMOS TRANSISTOR MODEL
//
//-----------------------------------------------------------------------
inline subckt modprf ( d g s b )
parameters w=1.0e-6 l=1.0e-6 nrd=0.0 nrs=0.0 ad=0.0 as=0.0 pd=0.0 ps=0.0 ng=1
+ mmvth_modprf=0.0 mmu0_modprf=0.0
+ dvthmat=(mv_modprf53+mmvth_modprf)*(1.03e-08/sqrt(l*w*ng)) dumat=(mu_modprf53+mmu0_modprf)*(7.1e-9/sqrt(l*w*ng))
// //
if (modprf==1){
// --------- Gate network ------------------------------
lg  (g 20 ) inductor l=1.000e-15
rg  (20 21 ) resistor r=((-5.800e-04/w+2.884e+02 )/ng+(-5.394e+05*w+1.596e+00)) isnoisy=yes
//
// --------- Drain network -----------------------------
ldrain ( d 13 ) inductor l=1.000e-15
rdrain ( 13 11 ) resistor r=(8.051e-04/(w*ng)+1.731e+00) isnoisy=yes
//
// --------- Source network -----------------------------
lsource ( s 33 ) inductor l=1.000e-15
rsource ( 33 31 ) resistor r=(8.051e-04/(w*ng)+1.731e+00) isnoisy=yes
//
// --------- Substrate network -------------------------
// Diodes are for n-type or p-type MOS transistors
//
djdb  ( 11 12 ) bulk_diode area=ad*ng perim=pd*ng
djsb  ( 31 32 ) bulk_diode area=as*ng perim=ps*ng
//
rsub1 ( 12 b ) resistor r=((1.064e-04/w+1.682e+02)/ng+(1.724e+06*w+(-2.292e+00))) isnoisy=yes
rsub2 ( 32 b ) resistor r=((1.064e-04/w+1.682e+02)/ng+(1.724e+06*w+(-2.292e+00))) isnoisy=yes
//
// --------- Ideal mos transistor ----------------------
modprf ( 11 21 31 b ) mosinsub l=l w=w*ng ad=0.0 as=0.0 pd=0.0 ps=0.0 nrd=0 nrs=0
}else
modprf ( d s ) resistor r=1e30
notvalid paramtest errorif=(modprf==0) \
message="
***************************************************
*
* pmosrf is not valid in selected process option.
*
***************************************************"
// Intrinsic MOS transistor
model mosinsub bsim3v3 version=3.1 type=p  capmod=2.0000e+00 \
 mobmod=1.0000e+00  nqsmod=0.0000e+00  noimod=3 \
   vbox=1.000e+03      k1=-3.223e-01 \
     k2=2.1602e-01      k3=1.1030e+01     k3b=-7.580e-01 \
    nch=1.8000e+17 vth0=-8.419e-01+dvthmat \
   voff=-1.170e-01    dvt0=1.6500e+00    dvt1=3.8680e-01 \
   dvt2=1.6590e-02    keta=-1.440e-02 \
 pscbe1=5.0000e+09  pscbe2=1.0000e-04 \
 alpha0=0.0000e+00   beta0=3.0000e+01 \
  dvt0w=1.8790e-01   dvt1w=7.3350e+04   dvt2w=-6.312e-03 \
     ua=5.3940e-10      ub=3.9760e-19      uc=1.0000e-20 \
u0=1.2040e+02+(1.2040e+02)*dumat \
   dsub=5.0000e-01    eta0=2.4800e-01    etab=-3.917e-03 \
nfactor=1.2140e+00 \
     em=4.1000e+07    pclm=1.8290e+00 \
  drout=5.0000e-01 \
     a0=5.8500e-01      a1=0.0000e+00      a2=1.0000e+00 \
   pvag=0.0000e+00    vsat=4.8240e+04     ags=2.4680e-01      b0=8.8320e-08      b1=0.0000e+00 \
  delta=1.0000e-02 pdiblcb=1.0000e+00 \
pdiblc1=1.0000e-04 pdiblc2=1.0000e-20 \
     w0=1.0000e-10 \
    dlc=5.6730e-08 \
    dwc=3.4490e-08     dwb=0.0000e+00     dwg=0.0000e+00 \
     ll=0.000e+00      lw=0.000e+00     lwl=0.000e+00 \
    lln=1.000e+00     lwn=1.000e+00      wl=0.0000e+00 \
     ww=1.8940e-16     wwl=-1.981e-21     wln=1.0000e+00 \
     wr=1.0000e+00     wwn=1.0400e+00 \
     at=3.3000e+04     ute=-1.300e+00 \
    kt1=-5.403e-01     kt2=2.2000e-02    kt1l=0.0000e+00 \
    ua1=0.0000e+00     ub1=0.0000e+00     uc1=0.0000e+00 \
    prt=0.0000e+00 \
   cgso=1.0000e-12    cgdo=1.0000e-12    cgbo=1.1000e-10 \
   cgdl=2.7947e-10    cgsl=2.7947e-10  ckappa=6.0000e-01 \
     cf=0.0000e+00     elm=5.0000e+00 \
  xpart=1.0000e+00     clc=1.0000e-15     cle=6.0000e-01 \
\
   rdsw=0.0000e+00 \
   cdsc=2.5890e-03   cdscb=2.9430e-04   cdscd=4.3700e-04 \
   prwb=-9.731e-02    prwg=1.4770e-01     cit=0.0000e+00 \
tox=7.6000e-09 \
  ngate=0.0000e+00 \
    nlx=1.7700e-07 \
     xl=4.0000e-08      xw=5.0000e-09 \
     af=1.4610e+00      kf=1.1910e-26      ef=1.0000e+00 \
   noia=5.2450e+17    noib=4.8160e+03    noic=8.0360e-13 \
     rd=0.0000e+00      rs=0.0000e+00     rsh=1.2900e+02 \
   minr=1.000e-03 \
    rdc=0.0000e+00     rsc=0.0000e+00 lint=-1.164e-08 \
wint=3.4490e-08   ldif=0.000e+00    hdif=8.0000e-07 \
     xj=3.0000e-07      js=2.8000e-07 \
      n=1.0000e+00 \
  dskip=no          tlev=0           tlevc=0         \
    jsw=3.7000e-13 \
     cj=0.0000e+00    cjsw=0.0000e+00 \
     fc=0.0000e+00    fcsw=0.000e+00 \
     mj=5.6000e-01    mjsw=4.3000e-01 \
     pb=1.0200e+00    pbsw=1.0200e+00     xti=1.9700e+00
// Bulk Diode Model
model bulk_diode diode level=1 dskip=no \
     is=2.800e-07      isw=3.700e-13       n=1.0000000       ns=1.0000000   \
    cjo=1.526e-03       m=1.176e-01 \
    cjsw=0.000e+00       mjsw=4.300e-01 \
     fc=0.000e+00      tt=0.000e+00      vj=1.020e+00      vjsw=1.020e+00  \
     kf=0.000e+00      eg=1.11e+00     xti=1.973e+00      af=1.000e+00
ends modprf
// ----------------------------------------------------------------------
//-------------- END OF Section ------------------
endsection
section cmoswz
//
// ----------------------------------------------------------------------
// Owner: austriamicrosystems
// HIT-Kit: Digital
// ************************ SIMULATION PARAMETERS ************************
//  ----------------------------------------------------------------------
//  format    : Spectre (Spectre Direct)
//  model     : MOS BSIM3v3
//  process   : C35
//  revision  : 4.0;
//  extracted : B10866 ; 2002-12; ese(5487)
//  doc#      : ENG-182 REV_6
//  ----------------------------------------------------------------------
//                         WORST CASE ZERO CONDITION
//
//  ----------------------------------------------------------------------
//
inline subckt modn ( d g s b )
parameters w=1.0e-6 l=1.0e-6 nrd=0.0 nrs=0.0 ad=0.0 as=0.0 pd=0.0 ps=0.0 ng=1
+ ws= w
+ ls= l
+ shk=1
+ dvthmat=(mv_modn)*(0.67e-08/sqrt(ls*ws*ng)) dumat=(mu_modn)*(4.9e-9/sqrt(ls*ws*ng))
//
if (modn==1)
modn ( d g s b ) mosinsub w=ws l=ls nrd=nrd nrs=nrs ad=ad as=as pd=pd ps=ps m=ng
else
modn ( d s ) resistor r=1e30
notvalid paramtest errorif=(modn==0) \
message="
***************************************************
*
* nmos is not valid in selected process option.
*
***************************************************"
model mosinsub bsim3v3 version=3.2400e+00  type=n  capmod=2.0000e+00 \
 mobmod=1.0000e+00  nqsmod=0.0000e+00  noimod=3 \
   vbox=1.000e+03      k1=6.1933e-01 \
     k2=1.9997e-02      k3=-1.136e+00     k3b=-4.399e-01 \
    nch=3.0940e+17 vth0=5.5790e-01+dvthmat \
   voff=-8.925e-02    dvt0=5.0000e+01    dvt1=1.0390e+00 \
   dvt2=-8.375e-03    keta=2.0320e-02 \
 pscbe1=1.0000e+30  pscbe2=1.0000e-06 \
 alpha0=2.6000e-06  alpha1=5.0000e+00   beta0=2.1000e+01 \
  dvt0w=1.0890e-01   dvt1w=6.6710e+04   dvt2w=-1.352e-02 \
     ua=4.7050e-12      ub=2.1370e-18      uc=1.0000e-20 \
u0=4.6710e+02+(4.6710e+02)*dumat \
   dsub=5.0000e-01    eta0=1.4150e-02    etab=-1.221e-01 \
nfactor=4.1360e-01 \
     em=4.1000e+07    pclm=6.9480e-01 \
  drout=5.0000e-01 \
     a0=2.5410e+00      a1=0.0000e+00      a2=1.0000e+00 \
   pvag=0.0000e+00    vsat=1.3380e+05     ags=2.4080e-01      b0=4.3010e-09      b1=0.0000e+00 \
  delta=1.4420e-02 pdiblcb=3.2220e-01 \
pdiblc1=3.5710e-01 pdiblc2=2.0650e-03 \
     w0=2.6730e-07 \
    dlc=3.0000e-08 \
    dwc=9.4030e-08     dwb=0.0000e+00     dwg=0.0000e+00 \
     ll=0.000e+00      lw=0.000e+00     lwl=0.000e+00 \
    lln=1.000e+00     lwn=1.000e+00      wl=0.0000e+00 \
     ww=-1.297e-14     wwl=-9.411e-21     wln=1.0000e+00 \
     wr=1.0000e+00     wwn=1.0000e+00 \
     at=3.3000e+04     ute=-1.800e+00 \
    kt1=-3.302e-01     kt2=2.2000e-02    kt1l=0.0000e+00 \
    ua1=0.0000e+00     ub1=0.0000e+00     uc1=0.0000e+00 \
    prt=0.0000e+00 \
   cgso=1.2000e-10    cgdo=1.2000e-10    cgbo=1.1000e-10 \
   cgdl=1.4167e-10    cgsl=1.4167e-10  ckappa=6.0000e-01 \
     cf=0.0000e+00     elm=5.0000e+00 \
  xpart=1.0000e+00     clc=1.0000e-15     cle=6.0000e-01 \
   noff=1.0000e+00  voffcv=0.0000e+00 \
   rdsw=3.4490e+02 \
   cdsc=0.0000e+00   cdscb=1.5000e-03   cdscd=1.0000e-03 \
   prwb=-2.416e-01    prwg=0.0000e+00     cit=4.4410e-04 \
tox=7.6000e-09 \
  ngate=0.0000e+00 \
    nlx=1.8880e-07 \
     xl=5.0000e-08      xw=-2.500e-08 \
     af=1.3760e+00      kf=3.3960e-26      ef=1.0000e+00 \
   noia=1.3990e+20    noib=2.7070e+05    noic=-4.680e-12 \
     rd=0.0000e+00      rs=0.0000e+00     rsh=8.5000e+01 \
   minr=1.000e-03 \
    rdc=0.0000e+00     rsc=0.0000e+00 lint=-5.005e-08 \
wint=9.4030e-08   ldif=0.000e+00    hdif=8.0000e-07 \
     xj=3.0000e-07      js=5.1000e-07 \
      n=1.0000e+00 \
  dskip=no          tlev=0           tlevc=0         \
    jsw=6.0000e-13 \
     cj=1.0520e-03    cjsw=2.8000e-10 \
     fc=0.0000e+00    fcsw=0.000e+00 \
     mj=3.4000e-01    mjsw=2.3000e-01 \
     pb=6.9000e-01    pbsw=6.9000e-01     xti=2.0260e+00
ends modn

// ----------------------------------------------------------------------
// ----------------------------------------------------------------------
// Owner: austriamicrosystems
// HIT-Kit: Digital
// ************************ SIMULATION PARAMETERS ************************
//  ----------------------------------------------------------------------
//  format    : Spectre (Spectre Direct)
//  model     : MOS BSIM3v3
//  process   : C35
//  revision  : 4.1;
//  extracted : B11004 ; 2002-12; ese(5487)
//  doc#      : ENG-182 REV_6
//  ----------------------------------------------------------------------
//                         WORST CASE ZERO CONDITION
//
//  ----------------------------------------------------------------------
//
inline subckt modnm ( d g s b )
parameters w=1.0e-6 l=1.0e-6 nrd=0.0 nrs=0.0 ad=0.0 as=0.0 pd=0.0 ps=0.0 ng=1
+ ws= w
+ ls= l
+ shk=1
+ dvthmat=(mv_modnm)*(1.03e-08/sqrt(ls*ws*ng)) dumat=(mu_modnm)*(3.5e-9/sqrt(ls*ws*ng))
//
if (modnm==1)
modnm ( d g s b ) mosinsub w=ws l=ls nrd=nrd nrs=nrs ad=ad as=as pd=pd ps=ps m=ng
else
modnm ( d s ) resistor r=1e30
notvalid paramtest errorif=(modnm==0) \
message="
***************************************************
*
* nmosm is not valid in selected process option.
*
***************************************************"
model mosinsub bsim3v3 version=3.2400e+00  type=n  capmod=2.0000e+00 \
 mobmod=1.0000e+00  nqsmod=0.0000e+00  noimod=3 \
   vbox=1.000e+03      k1=8.1646e-01 \
     k2=1.0194e-01      k3=-3.776e+00     k3b=-7.691e-02 \
    nch=2.4590e+17 vth0=8.2950e-01+dvthmat \
   voff=-8.295e-02    dvt0=3.0000e+01    dvt1=1.5280e+00 \
   dvt2=2.5290e-02    keta=3.5850e-02 \
 pscbe1=1.0000e+30  pscbe2=1.0000e-06 \
 alpha0=7.7410e-09  alpha1=3.9830e-01   beta0=2.0700e+01 \
  dvt0w=-5.000e+00   dvt1w=2.5780e+06   dvt2w=5.1050e-02 \
     ua=4.7080e-10      ub=1.4700e-18      uc=-4.342e-11 \
u0=5.0210e+02+(5.0210e+02)*dumat \
   dsub=5.0000e-01    eta0=3.7950e-02    etab=-7.653e-04 \
nfactor=8.5730e-01 \
     em=4.1000e+07    pclm=2.1250e-01 \
  drout=5.0000e-01 \
     a0=2.0640e+00      a1=0.0000e+00      a2=1.0000e+00 \
   pvag=0.0000e+00    vsat=1.0780e+05     ags=1.0790e-01      b0=-1.493e-07      b1=0.0000e+00 \
  delta=1.0000e-02 pdiblcb=5.1860e-01 \
pdiblc1=1.0000e-04 pdiblc2=5.4580e-04 \
     w0=1.6170e-07 \
    dlc=1.0000e-07 \
    dwc=1.6230e-07     dwb=0.0000e+00     dwg=0.0000e+00 \
     ll=0.000e+00      lw=0.000e+00     lwl=0.000e+00 \
    lln=1.000e+00     lwn=1.000e+00      wl=0.0000e+00 \
     ww=-5.117e-14     wwl=-5.704e-21     wln=1.0000e+00 \
     wr=1.0000e+00     wwn=1.0000e+00 \
     at=3.3000e+04     ute=-1.760e+00 \
    kt1=-4.502e-01     kt2=2.2000e-02    kt1l=0.0000e+00 \
    ua1=0.0000e+00     ub1=0.0000e+00     uc1=0.0000e+00 \
    prt=0.0000e+00 \
   cgso=1.0800e-10    cgdo=1.0800e-10    cgbo=1.1000e-10 \
   cgdl=2.4500e-10    cgsl=2.4500e-10  ckappa=6.0000e-01 \
     cf=0.0000e+00     elm=5.0000e+00 \
  xpart=1.0000e+00     clc=1.0000e-15     cle=6.0000e-01 \
   noff=1.0000e+00  voffcv=0.0000e+00 \
   rdsw=1.3900e+03 \
   cdsc=0.0000e+00   cdscb=-1.500e-03   cdscd=0.0000e+00 \
   prwb=-6.740e-02    prwg=0.0000e+00     cit=0.0000e+00 \
tox=1.5000e-08 \
  ngate=0.0000e+00 \
    nlx=2.2830e-07 \
     xl=8.0000e-08      xw=-5.000e-08 \
     af=1.3580e+00      kf=3.4460e-26      ef=1.0000e+00 \
   noia=1.7020e+20    noib=5.4630e+05    noic=-1.400e-11 \
     rd=0.0000e+00      rs=0.0000e+00     rsh=8.5000e+01 \
   minr=1.000e-03 \
    rdc=0.0000e+00     rsc=0.0000e+00 lint=1.2250e-07 \
wint=1.6230e-07   ldif=0.000e+00    hdif=6.0000e-07 \
     xj=3.0000e-07      js=5.1000e-07 \
      n=1.0000e+00 \
  dskip=no          tlev=0           tlevc=0         \
    jsw=6.0000e-13 \
     cj=1.0530e-03    cjsw=2.8000e-10 \
     fc=0.0000e+00    fcsw=0.000e+00 \
     mj=3.4000e-01    mjsw=2.3000e-01 \
     pb=6.9000e-01    pbsw=6.9000e-01     xti=2.0260e+00
ends modnm

// ----------------------------------------------------------------------

// ----------------------------------------------------------------------
// Owner: austriamicrosystems
// HIT-Kit: Digital
// ************************ SIMULATION PARAMETERS ************************
//  ----------------------------------------------------------------------
//  format    : Spectre (Spectre Direct)
//  model     : MOS BSIM3v3
//  process   : C35
//  revision  : 5.0;
//  extracted : B27167L1W5C45; 15-04-2007; bse (5866)
//  doc#      : Eng-182 REV_6
//  ----------------------------------------------------------------------
//                         WORST CASE ZERO CONDITION
//
//  ----------------------------------------------------------------------
//
inline subckt modnl ( d g s b )
parameters w=1.0e-6 l=1.0e-6 nrd=0.0 nrs=0.0 ad=0.0 as=0.0 pd=0.0 ps=0.0 ng=1
+ ws= w
+ ls= l
+ shk=1
+ dvthmat=(mv_modnl)*(0.67e-08/sqrt(ls*ws*ng)) dumat=(mu_modnl)*(4.9e-9/sqrt(ls*ws*ng))
//
if (modnl==1)
modnl ( d g s b ) mosinsub w=ws l=ls nrd=8.0000e-07/ws nrs=8.0000e-07/ws ad=ad as=as pd=pd ps=ps m=ng
else
modnl ( d s ) resistor r=1e30
notvalid paramtest errorif=(modnl==0) \
message="
***************************************************
*
* nmosl is not valid in selected process option.
*
***************************************************"
model mosinsub bsim3v3 version=3.2400e+00  type=n  capmod=2.0000e+00 \
 mobmod=1.0000e+00  nqsmod=0.0000e+00  noimod=3.0000e+00 \
   vbox=1.000e+03      k1=5.4000e-01 \
     k2=0.0000e+00      k3=7.6040e+00     k3b=0.0000e+00 \
    nch=2.7400e+17 vth0=5.0200e-01+dvthmat \
   voff=-8.000e-02    dvt0=1.2570e+01    dvt1=8.1290e-01 \
   dvt2=2.2200e-15    keta=-2.800e-03 \
 pscbe1=1.0000e+30  pscbe2=1.0000e-06 \
 alpha0=1.9000e-06  alpha1=1.0000e+00   beta0=2.0000e+01 \
  dvt0w=0.0000e+00   dvt1w=1.6970e+06   dvt2w=2.5060e-01 \
     ua=1.0000e-12      ub=2.1880e-18      uc=7.2440e-11 \
u0=4.2560e+02+(4.2560e+02)*dumat \
   dsub=5.0000e-01    eta0=5.1580e-02    etab=-6.600e-02 \
nfactor=1.0000e+00 \
     em=4.1000e+07    pclm=1.2650e+00 \
  drout=5.0000e-01 \
     a0=1.7080e+00      a1=0.0000e+00      a2=1.0000e+00 \
   pvag=3.1500e-01    vsat=9.4190e+04     ags=3.1620e-01      b0=2.6240e-08      b1=0.0000e+00 \
  delta=1.0000e-03 pdiblcb=3.6000e-01 \
pdiblc1=1.2970e-01 pdiblc2=1.9500e-03 \
     w0=2.5000e-06 \
    dlc=3.0000e-08 \
    dwc=9.5120e-08     dwb=0.0000e+00     dwg=-7.686e-09 \
     ll=6.3200e-15      lw=0.0000e+00     lwl=0.0000e+00 \
    lln=1.0000e+00     lwn=1.0000e+00      wl=0.0000e+00 \
     ww=-2.855e-14     wwl=-4.365e-21     wln=1.0000e+00 \
     wr=1.0000e+00     wwn=1.0000e+00 \
     at=1.0000e+04     ute=-1.700e+00 \
    kt1=-3.400e-01     kt2=-4.840e-02    kt1l=0.0000e+00 \
    ua1=0.0000e+00     ub1=0.0000e+00     uc1=0.0000e+00 \
    prt=0.0000e+00 \
   cgso=1.2000e-11    cgdo=1.2000e-11    cgbo=1.1000e-10 \
   cgdl=3.8333e-10    cgsl=3.8333e-10  ckappa=1.7010e+00 \
     cf=0.0000e+00     elm=5.0000e+00 \
  xpart=1.0000e+00     clc=1.0000e-15     cle=6.0000e-01 \
\
   rdsw=4.4670e+02 \
   cdsc=1.0000e-09   cdscb=0.0000e+00   cdscd=0.0000e+00 \
   prwb=0.0000e+00    prwg=1.9050e-02     cit=0.0000e+00 \
tox=7.6000e-09 \
  ngate=0.0000e+00 \
    nlx=1.4300e-07 \
     xl=8.6000e-08      xw=-7.980e-09 \
     af=1.4940e+00      kf=6.9860e-26      ef=1.0000e+00 \
   noia=9.8640e+19    noib=1.7020e+05    noic=-2.723e-12 \
     rd=0.0000e+00      rs=0.0000e+00     rsh=8.5000e+01 \
   minr=1.000e-03 \
    rdc=0.0000e+00     rsc=0.0000e+00 lint=-6.902e-09 \
wint=9.5120e-08   ldif=0.000e+00    hdif=8.0000e-07 \
     xj=3.0000e-07      js=5.1000e-07 \
      n=1.0000e+00 \
  dskip=no          tlev=0           tlevc=0         \
    jsw=6.0000e-13 \
     cj=9.9600e-04    cjsw=3.0000e-10 \
     fc=0.0000e+00    fcsw=0.000e+00 \
     mj=3.4000e-01    mjsw=2.3000e-01 \
     pb=6.9000e-01    pbsw=6.9000e-01     xti=2.0300e+00
ends modnl

// ----------------------------------------------------------------------

// ----------------------------------------------------------------------
// Owner: austriamicrosystems
// HIT-Kit: Digital
// ************************ SIMULATION PARAMETERS ************************
//  ----------------------------------------------------------------------
//  format    : Spectre (Spectre Direct)
//  model     : MOS BSIM3v3
//  process   : C35
//  revision  : 5.0;
//  extracted : B27167L1W5C45; 15-04-2007; bse (5866)
//  doc#      : Eng-182 REV_6
//  ----------------------------------------------------------------------
//                         WORST CASE ZERO CONDITION
//
//  ----------------------------------------------------------------------
//
inline subckt modnml ( d g s b )
parameters w=1.0e-6 l=1.0e-6 nrd=0.0 nrs=0.0 ad=0.0 as=0.0 pd=0.0 ps=0.0 ng=1
+ ws= w
+ ls= l
+ shk=1
+ dvthmat=(mv_modnml)*(0.95e-08/sqrt(ls*ws*ng)) dumat=(mu_modnml)*(3.5e-9/sqrt(ls*ws*ng))
//
if (modnml==1)
modnml ( d g s b ) mosinsub w=ws l=ls nrd=6.0000e-07/ws nrs=6.0000e-07/ws ad=ad as=as pd=pd ps=ps m=ng
else
modnml ( d s ) resistor r=1e30
notvalid paramtest errorif=(modnml==0) \
message="
***************************************************
*
* nmosml is not valid in selected process option.
*
***************************************************"
model mosinsub bsim3v3 version=3.2400e+00  type=n  capmod=2.0000e+00 \
 mobmod=1.0000e+00  nqsmod=0.0000e+00  noimod=3.0000e+00 \
   vbox=1.000e+03      k1=9.8000e-01 \
     k2=0.0000e+00      k3=-1.456e+00     k3b=-7.244e-01 \
    nch=1.7150e+17 vth0=6.7940e-01+dvthmat \
   voff=-8.684e-02    dvt0=1.6010e+01    dvt1=1.0610e+00 \
   dvt2=4.5970e-02    keta=1.9180e-02 \
 pscbe1=1.0000e+30  pscbe2=1.0000e-06 \
 alpha0=1.6220e-08  alpha1=1.3800e-01   beta0=2.1000e+01 \
  dvt0w=0.0000e+00   dvt1w=3.0990e+06   dvt2w=4.5170e-02 \
     ua=1.0000e-12      ub=2.2910e-18      uc=6.9180e-11 \
u0=4.2930e+02+(4.2930e+02)*dumat \
   dsub=5.0000e-01    eta0=5.1290e-02    etab=-5.126e-03 \
nfactor=9.6050e-01 \
     em=4.1000e+07    pclm=1.1380e+00 \
  drout=5.0000e-01 \
     a0=1.0460e+00      a1=0.0000e+00      a2=1.0000e+00 \
   pvag=5.0000e-02    vsat=8.4420e+04     ags=1.2000e-01      b0=0.0000e+00      b1=0.0000e+00 \
  delta=1.8640e-03 pdiblcb=9.7980e-01 \
pdiblc1=6.1030e-06 pdiblc2=7.2440e-04 \
     w0=3.3160e-08 \
    dlc=1.0000e-07 \
    dwc=1.1660e-07     dwb=5.8200e-09     dwg=-1.000e-09 \
     ll=-9.793e-15      lw=0.0000e+00     lwl=0.0000e+00 \
    lln=1.0000e+00     lwn=1.0000e+00      wl=0.0000e+00 \
     ww=-4.017e-14     wwl=-1.380e-21     wln=1.0000e+00 \
     wr=1.0000e+00     wwn=1.0000e+00 \
     at=4.3550e+04     ute=-1.720e+00 \
    kt1=-4.500e-01     kt2=-6.560e-02    kt1l=0.0000e+00 \
    ua1=2.7540e-10     ub1=0.0000e+00     uc1=0.0000e+00 \
    prt=2.0000e+02 \
   cgso=1.0000e-12    cgdo=1.0000e-12    cgbo=1.1000e-10 \
   cgdl=4.6867e-10    cgsl=4.6867e-10  ckappa=1.9040e+00 \
     cf=0.0000e+00     elm=5.0000e+00 \
  xpart=1.0000e+00     clc=1.0000e-15     cle=6.0000e-01 \
\
   rdsw=1.1940e+03 \
   cdsc=2.4000e-04   cdscb=-7.468e-04   cdscd=0.0000e+00 \
   prwb=5.2110e-02    prwg=-5.443e-02     cit=0.0000e+00 \
tox=1.5000e-08 \
  ngate=1.0000e+00 \
    nlx=2.3690e-07 \
     xl=9.3920e-08      xw=-1.100e-08 \
     af=1.4000e+00      kf=3.7700e-26      ef=1.0000e+00 \
   noia=1.5360e+20    noib=3.5840e+05    noic=-1.304e-11 \
     rd=0.0000e+00      rs=0.0000e+00     rsh=8.5000e+01 \
   minr=1.000e-03 \
    rdc=0.0000e+00     rsc=0.0000e+00 lint=1.1900e-07 \
wint=1.1660e-07   ldif=0.000e+00    hdif=6.0000e-07 \
     xj=3.0000e-07      js=5.1000e-07 \
      n=1.0000e+00 \
  dskip=no          tlev=0           tlevc=0         \
    jsw=6.0000e-13 \
     cj=9.9600e-03    cjsw=3.0000e-10 \
     fc=0.0000e+00    fcsw=0.000e+00 \
     mj=3.4000e-01    mjsw=2.3000e-01 \
     pb=6.9000e-01    pbsw=6.9000e-01     xti=2.0300e+00
ends modnml

// ----------------------------------------------------------------------
// ----------------------------------------------------------------------
// Owner: austriamicrosystems
// HIT-Kit: Digital
// ************************ SIMULATION PARAMETERS ************************
//  ----------------------------------------------------------------------
//  format    : Spectre (Spectre Direct)
//  model     : MOS BSIM3v3
//  process   : C35
//  revision  : 4.1;
//  extracted : C64685 ; 2002-12; ese(5487)
//  doc#      : ENG-182 REV_6
//  ----------------------------------------------------------------------
//                         WORST CASE ZERO CONDITION
//
//  ----------------------------------------------------------------------
//
inline subckt modpm ( d g s b )
parameters w=1.0e-6 l=1.0e-6 nrd=0.0 nrs=0.0 ad=0.0 as=0.0 pd=0.0 ps=0.0 ng=1
+ ws= w
+ ls= l
+ shk=1
+ dvthmat=(mv_modpm)*(1.5e-08/sqrt(ls*ws*ng)) dumat=(mu_modpm)*(7.1e-9/sqrt(ls*ws*ng))
//
if (modpm==1)
modpm ( d g s b ) mosinsub w=ws l=ls nrd=nrd nrs=nrs ad=ad as=as pd=pd ps=ps m=ng
else
modpm ( d s ) resistor r=1e30
notvalid paramtest errorif=(modpm==0) \
message="
***************************************************
*
* pmosm is not valid in selected process option.
*
***************************************************"
model mosinsub bsim3v3 version=3.2400e+00  type=p  capmod=2.0000e+00 \
 mobmod=1.0000e+00  nqsmod=0.0000e+00  noimod=3 \
   vbox=1.000e+03      k1=5.2612e-01 \
     k2=4.9759e-02      k3=8.3170e+00     k3b=-1.479e+00 \
    nch=7.4830e+16 vth0=-8.510e-01+dvthmat \
   voff=-1.148e-01    dvt0=5.3990e-01    dvt1=4.1120e-01 \
   dvt2=-9.479e-02    keta=3.0100e-02 \
 pscbe1=1.0000e+30  pscbe2=1.0000e-06 \
 alpha0=2.7100e-07  alpha1=1.9100e+00   beta0=3.4770e+01 \
  dvt0w=8.0990e-01   dvt1w=1.4800e+05   dvt2w=4.4040e-02 \
     ua=1.8000e-12      ub=2.2180e-18      uc=-7.278e-11 \
u0=1.5130e+02+(1.5130e+02)*dumat \
   dsub=5.0000e-01    eta0=9.7360e-02    etab=-2.948e-02 \
nfactor=7.0460e-01 \
     em=4.1000e+07    pclm=4.3950e+00 \
  drout=5.0000e-01 \
     a0=1.3860e+00      a1=0.0000e+00      a2=1.0000e+00 \
   pvag=0.0000e+00    vsat=1.4360e+05     ags=1.3640e-01      b0=1.9910e-08      b1=0.0000e+00 \
  delta=1.0000e-02 pdiblcb=1.0000e+00 \
pdiblc1=2.0370e-02 pdiblc2=1.0000e-20 \
     w0=1.0000e-10 \
    dlc=2.5000e-08 \
    dwc=6.2030e-08     dwb=0.0000e+00     dwg=0.0000e+00 \
     ll=0.000e+00      lw=0.000e+00     lwl=0.000e+00 \
    lln=1.000e+00     lwn=1.000e+00      wl=0.0000e+00 \
     ww=-9.750e-16     wwl=-1.787e-21     wln=1.0000e+00 \
     wr=1.0000e+00     wwn=1.0400e+00 \
     at=3.3000e+04     ute=-1.300e+00 \
    kt1=-6.003e-01     kt2=2.2000e-02    kt1l=0.0000e+00 \
    ua1=0.0000e+00     ub1=0.0000e+00     uc1=0.0000e+00 \
    prt=0.0000e+00 \
   cgso=9.1000e-11    cgdo=9.1000e-11    cgbo=1.1000e-10 \
   cgdl=5.4667e-11    cgsl=5.4667e-11  ckappa=6.0000e-01 \
     cf=0.0000e+00     elm=5.0000e+00 \
  xpart=1.0000e+00     clc=1.0000e-15     cle=6.0000e-01 \
   noff=1.0000e+00  voffcv=0.0000e+00 \
   rdsw=1.6230e+03 \
   cdsc=1.2140e-03   cdscb=2.9450e-04   cdscd=0.0000e+00 \
   prwb=-4.521e-01    prwg=0.0000e+00     cit=5.2590e-05 \
tox=1.5000e-08 \
  ngate=0.0000e+00 \
    nlx=2.2310e-07 \
     xl=-5.000e-08      xw=0.0000e+00 \
     af=1.5640e+00      kf=4.8520e-26      ef=1.0000e+00 \
   noia=1.8720e+18    noib=3.4540e+04    noic=1.2460e-12 \
     rd=0.0000e+00      rs=0.0000e+00     rsh=1.0080e+02 \
   minr=1.000e-03 \
    rdc=0.0000e+00     rsc=0.0000e+00 lint=-8.504e-08 \
wint=6.2030e-08   ldif=0.000e+00    hdif=6.0000e-07 \
     xj=3.0000e-07      js=2.8000e-07 \
      n=1.0000e+00 \
  dskip=no          tlev=0           tlevc=0         \
    jsw=3.7000e-13 \
     cj=1.1960e-03    cjsw=2.8100e-10 \
     fc=0.0000e+00    fcsw=0.000e+00 \
     mj=5.4000e-01    mjsw=4.6000e-01 \
     pb=1.0200e+00    pbsw=1.0200e+00     xti=1.9700e+00
ends modpm

// ----------------------------------------------------------------------

// ----------------------------------------------------------------------
// Owner: austriamicrosystems
// HIT-Kit: Digital
// ************************ SIMULATION PARAMETERS ************************
//  ----------------------------------------------------------------------
//  format    : Spectre (Spectre Direct)
//  model     : MOS BSIM3v3
//  process   : C35
//  revision  : 5.0;
//  extracted : B27167L1W5C45; 15-04-2007; bse (5866)
//  doc#      : Eng-182 REV_6
//  ----------------------------------------------------------------------
//                         WORST CASE ZERO CONDITION
//
//  ----------------------------------------------------------------------
//
inline subckt modpml ( d g s b )
parameters w=1.0e-6 l=1.0e-6 nrd=0.0 nrs=0.0 ad=0.0 as=0.0 pd=0.0 ps=0.0 ng=1
+ ws= w
+ ls= l
+ shk=1
+ dvthmat=(mv_modpml)*(1.8e-08/sqrt(ls*ws*ng)) dumat=(mu_modpml)*(6.3e-9/sqrt(ls*ws*ng))
//
if (modpml==1)
modpml ( d g s b ) mosinsub w=ws l=ls nrd=6.0000e-07/ws nrs=6.0000e-07/ws ad=ad as=as pd=pd ps=ps m=ng
else
modpml ( d s ) resistor r=1e30
notvalid paramtest errorif=(modpml==0) \
message="
***************************************************
*
* pmosml is not valid in selected process option.
*
***************************************************"
model mosinsub bsim3v3 version=3.2400e+00  type=p  capmod=2.0000e+00 \
 mobmod=1.0000e+00  nqsmod=0.0000e+00  noimod=3.0000e+00 \
   vbox=1.000e+03      k1=6.7600e-01 \
     k2=-4.000e-03      k3=1.7420e+01     k3b=-1.738e+00 \
    nch=5.6580e+16 vth0=-5.880e-01+dvthmat \
   voff=-1.960e-01    dvt0=1.0000e+00    dvt1=4.2050e-01 \
   dvt2=-4.410e-02    keta=6.0000e-03 \
 pscbe1=1.0000e+30  pscbe2=1.0000e-06 \
 alpha0=1.3000e-07  alpha1=3.3320e-02   beta0=2.4820e+01 \
  dvt0w=5.7320e-01   dvt1w=2.8750e+05   dvt2w=1.6680e-01 \
     ua=3.3110e-09      ub=1.0000e-19      uc=-8.710e-11 \
u0=2.6590e+02+(2.6590e+02)*dumat \
   dsub=5.0000e-01    eta0=1.2500e-01    etab=-3.726e-04 \
nfactor=1.0210e+00 \
     em=4.1000e+07    pclm=2.5000e+00 \
  drout=5.0000e-01 \
     a0=1.1720e+00      a1=-1.581e-01      a2=1.0000e+00 \
   pvag=0.0000e+00    vsat=1.5690e+05     ags=1.4450e-01      b0=6.1800e-08      b1=0.0000e+00 \
  delta=2.9180e-02 pdiblcb=8.4520e-01 \
pdiblc1=1.1270e-02 pdiblc2=1.2500e-03 \
     w0=1.3800e-06 \
    dlc=4.5000e-08 \
    dwc=1.2300e-07     dwb=5.5110e-09     dwg=-5.171e-09 \
     ll=0.0000e+00      lw=0.0000e+00     lwl=0.0000e+00 \
    lln=1.0000e+00     lwn=1.0000e+00      wl=0.0000e+00 \
     ww=-4.460e-14     wwl=0.0000e+00     wln=1.0000e+00 \
     wr=1.0000e+00     wwn=1.0000e+00 \
     at=3.0000e+03     ute=-1.628e+00 \
    kt1=-6.603e-01     kt2=-8.840e-02    kt1l=0.0000e+00 \
    ua1=-2.399e-09     ub1=0.0000e+00     uc1=0.0000e+00 \
    prt=0.0000e+00 \
   cgso=6.4000e-11    cgdo=6.4000e-11    cgbo=1.1000e-10 \
   cgdl=1.4667e-10    cgsl=1.4667e-10  ckappa=1.4370e+00 \
     cf=0.0000e+00     elm=5.0000e+00 \
  xpart=1.0000e+00     clc=1.0000e-15     cle=6.0000e-01 \
\
   rdsw=6.3530e+02 \
   cdsc=1.4540e-04   cdscb=-2.792e-05   cdscd=0.0000e+00 \
   prwb=-3.097e-01    prwg=0.0000e+00     cit=0.0000e+00 \
tox=1.5000e-08 \
  ngate=1.0000e+00 \
    nlx=2.9510e-07 \
     xl=-6.000e-08      xw=-2.920e-09 \
     af=1.4710e+00      kf=1.3230e-26      ef=1.0000e+00 \
   noia=1.1970e+19    noib=2.6610e+04    noic=6.7840e-13 \
     rd=0.0000e+00      rs=0.0000e+00     rsh=1.1500e+02 \
   minr=1.000e-03 \
    rdc=0.0000e+00     rsc=0.0000e+00 lint=-7.553e-08 \
wint=1.2300e-07   ldif=0.000e+00    hdif=6.0000e-07 \
     xj=3.0000e-07      js=2.8000e-07 \
      n=1.0000e+00 \
  dskip=no          tlev=0           tlevc=0         \
    jsw=3.7000e-13 \
     cj=1.0880e-03    cjsw=2.8000e-10 \
     fc=0.0000e+00    fcsw=0.000e+00 \
     mj=5.4000e-01    mjsw=4.6000e-01 \
     pb=1.0200e+00    pbsw=1.0200e+00     xti=1.9700e+00
ends modpml

// ----------------------------------------------------------------------
//----------------------------------------------------------------------
//************************* SIMULATION PARAMETERS ************************
// ----------------------------------------------------------------------
// format    : Spectre ( Spectre Direct )
// model     : DIODE
// process   : C35
// revision  : 4.0;
// extracted : B10866 ; 2002-12; ese(5487)
// doc#      : ENG-182 REV_6
// ----------------------------------------------------------------------
//                        WORST CASE ZERO CONDITION
// ----------------------------------------------------------------------
// TERMINALS: A=anode=P-region C=cathode=N-region
// VARIABLES: M (mulitiplier), AREA [m^2], PERI [m].
// NOTE: The role of a protection DIODE is to conduct ESD current to VDD
// (or from VSS). This forward bias is NOT modelled, only leakage current
// and capacitance during normal operation. Any inductive load etc that
// will give forward bias, must be limited by other components to within
// Operating Conditions, otherwise parasitic bipolar action can occur.
//
// Parameters: area perim
//
inline subckt nd ( a c )
parameters area=1.0e-12 perimeter=1.0e-6
//
if (subdiode==1)
nd ( a c ) diodeinsub area=area perim=perimeter region=off
else
nd ( a c ) resistor r=1e30
notvalid paramtest errorif=(subdiode==0) \
message="
***************************************************
*
* subdiode is not valid in selected process option.
*
***************************************************"
model diodeinsub diode level=1 dskip=no \
     is=5.1000e-07     isw=6.0000e-13       n=1.0000e+00      ns=1.0000e+00 \
   minr=0.100e+00    imax=(1.000e+00/area) \
    cjo=1.0520e-03       m=3.4000e-01      vj=6.9000e-01      tt=0.000e+00 \
    xti=2.0260e+00 \
   cjsw=2.8000e-10    mjsw=2.3000e-01    vjsw=6.9000e-01      fc=0.000e+00 \
     af=1.000e+00      kf=0.000e+00
ends nd
// ----------------------------------------------------------------------
// Owner: austriamicrosystems
// HIT-Kit: Digital
// ************************ SIMULATION PARAMETERS ************************
//  ----------------------------------------------------------------------
//  format    : Spectre (Spectre Direct)
//  model     : MOS BSIM3v3
//  process   : C35
//  revision  : 4.1;
//  extracted : C64685 ; 2002-12; ese(5487)
//  doc#      : ENG-182 REV_6
//  ----------------------------------------------------------------------
//                         WORST CASE ZERO CONDITION
//
//  ----------------------------------------------------------------------
//
inline subckt modp ( d g s b )
parameters w=1.0e-6 l=1.0e-6 nrd=0.0 nrs=0.0 ad=0.0 as=0.0 pd=0.0 ps=0.0 ng=1
+ ws= w
+ ls= l
+ shk=1
+ dvthmat=(mv_modp)*(1.03e-08/sqrt(ls*ws*ng)) dumat=(mu_modp)*(7.1e-9/sqrt(ls*ws*ng))
//
if (modp==1)
modp ( d g s b ) mosinsub w=ws l=ls nrd=nrd nrs=nrs ad=ad as=as pd=pd ps=ps m=ng
else
modp ( d s ) resistor r=1e30
notvalid paramtest errorif=(modp==0) \
message="
***************************************************
*
* pmos is not valid in selected process option.
*
***************************************************"
model mosinsub bsim3v3 version=3.2400e+00  type=p  capmod=2.0000e+00 \
 mobmod=1.0000e+00  nqsmod=0.0000e+00  noimod=3 \
   vbox=1.000e+03      k1=4.8198e-01 \
     k2=-4.764e-02      k3=1.1030e+01     k3b=-7.580e-01 \
    nch=7.0220e+16 vth0=-5.715e-01+dvthmat \
   voff=-1.170e-01    dvt0=1.6500e+00    dvt1=3.8680e-01 \
   dvt2=1.6590e-02    keta=-1.440e-02 \
 pscbe1=1.0000e+30  pscbe2=1.0000e-06 \
 alpha0=1.0000e-09  alpha1=1.5000e+00   beta0=3.2500e+01 \
  dvt0w=1.8790e-01   dvt1w=7.3350e+04   dvt2w=-6.312e-03 \
     ua=5.3940e-10      ub=1.0530e-18      uc=1.0000e-20 \
u0=1.5810e+02+(1.5810e+02)*dumat \
   dsub=5.0000e-01    eta0=2.4800e-01    etab=-3.917e-03 \
nfactor=1.2140e+00 \
     em=4.1000e+07    pclm=3.1840e+00 \
  drout=5.0000e-01 \
     a0=5.8500e-01      a1=0.0000e+00      a2=1.0000e+00 \
   pvag=0.0000e+00    vsat=1.1580e+05     ags=2.4680e-01      b0=8.8320e-08      b1=0.0000e+00 \
  delta=1.0000e-02 pdiblcb=1.0000e+00 \
pdiblc1=1.0000e-04 pdiblc2=1.0000e-20 \
     w0=1.0000e-10 \
    dlc=2.4500e-08 \
    dwc=3.4490e-08     dwb=0.0000e+00     dwg=0.0000e+00 \
     ll=0.000e+00      lw=0.000e+00     lwl=0.000e+00 \
    lln=1.000e+00     lwn=1.000e+00      wl=0.0000e+00 \
     ww=1.8940e-16     wwl=-1.981e-21     wln=1.0000e+00 \
     wr=1.0000e+00     wwn=1.0400e+00 \
     at=3.3000e+04     ute=-1.300e+00 \
    kt1=-5.403e-01     kt2=2.2000e-02    kt1l=0.0000e+00 \
    ua1=0.0000e+00     ub1=0.0000e+00     uc1=0.0000e+00 \
    prt=0.0000e+00 \
   cgso=8.6000e-11    cgdo=8.6000e-11    cgbo=1.1000e-10 \
   cgdl=9.9333e-11    cgsl=9.9333e-11  ckappa=6.0000e-01 \
     cf=0.0000e+00     elm=5.0000e+00 \
  xpart=1.0000e+00     clc=1.0000e-15     cle=6.0000e-01 \
   noff=1.0000e+00  voffcv=0.0000e+00 \
   rdsw=1.0330e+03 \
   cdsc=2.5890e-03   cdscb=2.9430e-04   cdscd=4.3700e-04 \
   prwb=-9.731e-02    prwg=1.4770e-01     cit=0.0000e+00 \
tox=7.6000e-09 \
  ngate=0.0000e+00 \
    nlx=1.7700e-07 \
     xl=-6.000e-08      xw=5.0000e-09 \
     af=1.4050e+00      kf=1.8270e-26      ef=1.0000e+00 \
   noia=7.0910e+18    noib=6.0740e+04    noic=3.7790e-13 \
     rd=0.0000e+00      rs=0.0000e+00     rsh=1.0000e+02 \
   minr=1.000e-03 \
    rdc=0.0000e+00     rsc=0.0000e+00 lint=-7.130e-08 \
wint=3.4490e-08   ldif=0.000e+00    hdif=8.0000e-07 \
     xj=3.0000e-07      js=2.8000e-07 \
      n=1.0000e+00 \
  dskip=no          tlev=0           tlevc=0         \
    jsw=3.7000e-13 \
     cj=1.1970e-03    cjsw=2.8100e-10 \
     fc=0.0000e+00    fcsw=0.000e+00 \
     mj=5.4000e-01    mjsw=4.6000e-01 \
     pb=1.0200e+00    pbsw=1.0200e+00     xti=1.9730e+00
ends modp

// ----------------------------------------------------------------------

// ----------------------------------------------------------------------
// Owner: austriamicrosystems
// HIT-Kit: Digital
// ************************ SIMULATION PARAMETERS ************************
//  ----------------------------------------------------------------------
//  format    : Spectre (Spectre Direct)
//  model     : MOS BSIM3v3
//  process   : C35
//  revision  : 5.0;
//  extracted : B27167L1W5C45; 15-04-2007; bse (5866)
//  doc#      : Eng-182 REV_6
//  ----------------------------------------------------------------------
//                         WORST CASE ZERO CONDITION
//
//  ----------------------------------------------------------------------
//
inline subckt modpl ( d g s b )
parameters w=1.0e-6 l=1.0e-6 nrd=0.0 nrs=0.0 ad=0.0 as=0.0 pd=0.0 ps=0.0 ng=1
+ ws= w
+ ls= l
+ shk=1
+ dvthmat=(mv_modpl)*(1.24e-08/sqrt(ls*ws*ng)) dumat=(mu_modpl)*(5.7e-9/sqrt(ls*ws*ng))
//
if (modpl==1)
modpl ( d g s b ) mosinsub w=ws l=ls nrd=8.0000e-07/ws nrs=8.0000e-07/ws ad=ad as=as pd=pd ps=ps m=ng
else
modpl ( d s ) resistor r=1e30
notvalid paramtest errorif=(modpl==0) \
message="
***************************************************
*
* pmosl is not valid in selected process option.
*
***************************************************"
model mosinsub bsim3v3 version=3.2400e+00  type=p  capmod=2.0000e+00 \
 mobmod=1.0000e+00  nqsmod=0.0000e+00  noimod=3.0000e+00 \
   vbox=1.000e+03      k1=6.8800e-01 \
     k2=-7.790e-02      k3=5.2610e+01     k3b=7.2440e+00 \
    nch=6.2010e+16 vth0=-4.440e-01+dvthmat \
   voff=-2.280e-01    dvt0=1.0460e+00    dvt1=3.9190e-01 \
   dvt2=1.9100e-03    keta=-2.400e-03 \
 pscbe1=1.0000e+30  pscbe2=1.0000e-06 \
 alpha0=1.1750e-08  alpha1=1.0000e-03   beta0=1.9580e+01 \
  dvt0w=1.0000e+00   dvt1w=5.3000e+06   dvt2w=9.5620e-02 \
     ua=1.0000e-12      ub=1.9050e-18      uc=6.3100e-11 \
u0=1.6050e+02+(1.6050e+02)*dumat \
   dsub=5.0000e-01    eta0=1.9590e-01    etab=0.0000e+00 \
nfactor=1.5790e+00 \
     em=4.1000e+07    pclm=8.2410e-01 \
  drout=5.0000e-01 \
     a0=5.0000e-01      a1=0.0000e+00      a2=1.0000e+00 \
   pvag=0.0000e+00    vsat=9.8190e+04     ags=2.6300e-01      b0=6.0600e-08      b1=0.0000e+00 \
  delta=4.3330e-03 pdiblcb=9.6330e-01 \
pdiblc1=1.0000e-03 pdiblc2=1.3800e-03 \
     w0=1.9050e-06 \
    dlc=2.0000e-08 \
    dwc=7.2920e-08     dwb=1.6220e-08     dwg=0.0000e+00 \
     ll=0.0000e+00      lw=0.0000e+00     lwl=0.0000e+00 \
    lln=1.0000e+00     lwn=1.0000e+00      wl=0.0000e+00 \
     ww=-2.000e-14     wwl=0.0000e+00     wln=1.0000e+00 \
     wr=1.0000e+00     wwn=1.0400e+00 \
     at=3.3000e+04     ute=-1.280e+00 \
    kt1=-5.577e-01     kt2=-6.560e-02    kt1l=0.0000e+00 \
    ua1=0.0000e+00     ub1=0.0000e+00     uc1=0.0000e+00 \
    prt=0.0000e+00 \
   cgso=5.6000e-11    cgdo=5.6000e-11    cgbo=1.1000e-10 \
   cgdl=2.2000e-10    cgsl=2.2000e-10  ckappa=5.6400e-01 \
     cf=0.0000e+00     elm=5.0000e+00 \
  xpart=1.0000e+00     clc=1.0000e-15     cle=6.0000e-01 \
\
   rdsw=2.0890e+03 \
   cdsc=1.3750e-03   cdscb=4.4880e-04   cdscd=1.9130e-04 \
   prwb=3.8020e-02    prwg=-1.047e-01     cit=0.0000e+00 \
tox=7.6000e-09 \
  ngate=1.0000e+00 \
    nlx=1.6220e-07 \
     xl=-3.170e-08      xw=1.0030e-09 \
     af=1.4690e+00      kf=1.2960e-26      ef=1.0000e+00 \
   noia=2.9220e+19    noib=1.7730e+04    noic=4.5200e-13 \
     rd=0.0000e+00      rs=0.0000e+00     rsh=1.1500e+02 \
   minr=1.000e-03 \
    rdc=0.0000e+00     rsc=0.0000e+00 lint=-1.285e-08 \
wint=7.2920e-08   ldif=0.000e+00    hdif=8.0000e-07 \
     xj=3.0000e-07      js=2.8000e-07 \
      n=1.0000e+00 \
  dskip=no          tlev=0           tlevc=0         \
    jsw=3.7000e-13 \
     cj=1.0880e-03    cjsw=2.8000e-10 \
     fc=0.0000e+00    fcsw=0.000e+00 \
     mj=5.4000e-01    mjsw=4.6000e-01 \
     pb=1.0200e+00    pbsw=1.0200e+00     xti=1.9700e+00
ends modpl

// ----------------------------------------------------------------------
//----------------------------------------------------------------------
//************************* SIMULATION PARAMETERS ************************
// ----------------------------------------------------------------------
// format    : Spectre ( Spectre Direct )
// model     : DIODE
// process   : C35
// revision  : 4.1;
// extracted : C64685 ; 2002-12; ese(5487)
// doc#      : ENG-182 REV_6
// ----------------------------------------------------------------------
//                        WORST CASE ZERO CONDITION
// ----------------------------------------------------------------------
// TERMINALS: A=anode=P-region C=cathode=N-region
// VARIABLES: M (mulitiplier), AREA [m^2], PERI [m].
// NOTE: The role of a protection DIODE is to conduct ESD current to VDD
// (or from VSS). This forward bias is NOT modelled, only leakage current
// and capacitance during normal operation. Any inductive load etc that
// will give forward bias, must be limited by other components to within
// Operating Conditions, otherwise parasitic bipolar action can occur.
//
// Parameters: area perim
//
inline subckt pd ( a c )
parameters area=1.0e-12 perimeter=1.0e-6
//
if (welldiode==1)
pd ( a c ) diodeinsub area=area perim=perimeter region=off
else
pd ( a c ) resistor r=1e30
notvalid paramtest errorif=(welldiode==0) \
message="
***************************************************
*
* welldiode is not valid in selected process option.
*
***************************************************"
model diodeinsub diode level=1 dskip=no \
     is=2.8000e-07     isw=3.7000e-13       n=1.0000e+00      ns=1.0000e+00 \
   minr=0.100e+00    imax=(1.000e+00/area) \
    cjo=1.1970e-03       m=5.4000e-01      vj=1.0200e+00      tt=0.000e+00 \
    xti=1.9730e+00 \
   cjsw=2.8100e-10    mjsw=4.6000e-01    vjsw=1.0200e+00      fc=0.000e+00 \
     af=1.000e+00      kf=0.000e+00
ends pd
// ----------------------------------------------------------------------
// Owner: austriamicrosystems
// HIT-Kit: Digital
// ************************ SIMULATION PARAMETERS ************************
//  ----------------------------------------------------------------------
//  format    : Spectre (Spectre Direct)
//  model     : MOS BSIM3v3
//  process   : C35
//  revision  : 4.1;
//  extracted : C35 B11004.L2; 2002-11; hhl(5481)
//  doc#      : Eng-182  REV_6.0
//  ----------------------------------------------------------------------
//                        WORST CASE ZERO CONDITION
//  ----------------------------------------------------------------------
//  HV-TRANSISTOR
//  ----------------------------------------------------------------------
inline subckt modnmh ( d g s b )
// Parameters: w l nrd nrs ad as pd ps
parameters w=1.0e-6 l=1.0e-6 nrd=0.0 nrs=0.0 ad=0.0 as=0.0 pd=0.0 ps=0.0 mult=1
+ ws=w
+ ls=l
+ dvthmat=mv_modnmh*(1.03e-08/sqrt(ls*ws*mult)) dumat=mu_modnmh*(3.5e-9/sqrt(ls*ws*mult))
//
if (modnmh==1){
modnmh ( d1 g s b ) mosinsub w=ws l=ls nrd=0 nrs=6.0000e-07/ws ad=ad as=as pd=pd ps=ps
rd ( d1 d ) resistor r=(1.9340e+03*4.0000e-06/(ws)) tc1=6.2000e-03
}else
modnmh ( d s ) resistor r=1e30
notvalid paramtest errorif=(modnmh==0) \
message="
***************************************************
*
* nmosmh is not valid in selected process option.
*
***************************************************"
//
model mosinsub bsim3v3 version=3.1 type=n  capmod=2.0000e+00 \
 mobmod=1.0000e+00  nqsmod=0.0000e+00  noimod=3 \
   vbox=1.000e+03      k1=1.0716e+00 \
     k2=3.7569e-02      k3=-2.439e+00     k3b=4.0770e-01 \
    nch=2.4110e+17 vth0=7.5490e-01+dvthmat \
   voff=-4.948e-02    dvt0=4.9850e+01    dvt1=1.6830e+00 \
   dvt2=4.1260e-02    keta=-7.397e-02 \
 pscbe1=4.0000e+10  pscbe2=1.0000e-10 \
 alpha0=0.0000e+00   beta0=3.0000e+01 \
  dvt0w=0.0000e+00   dvt1w=0.0000e+00   dvt2w=0.0000e+00 \
     ua=1.0000e-12      ub=3.7680e-19      uc=6.3910e-12 \
u0=3.7650e+02+(3.7650e+02)*dumat \
   dsub=5.0000e-01    eta0=1.6160e-03    etab=-1.373e-02 \
nfactor=3.4550e-01 \
     em=4.1000e+07    pclm=1.0550e-01 \
  drout=5.0000e-01 \
     a0=2.1900e-01      a1=0.0000e+00      a2=1.0000e+00 \
   pvag=0.0000e+00    vsat=5.1290e+04     ags=9.4480e-02      b0=-3.629e-08      b1=0.0000e+00 \
  delta=3.3700e-03 pdiblcb=3.8720e-01 \
pdiblc1=1.0000e-10 pdiblc2=1.0000e-10 \
     w0=6.2890e-08 \
    dlc=8.9170e-08 \
    dwc=4.9380e-08     dwb=0.0000e+00     dwg=0.0000e+00 \
     ll=0.0000e+00      lw=0.0000e+00     lwl=0.0000e+00 \
    lln=1.0000e+00     lwn=1.0000e+00      wl=0.0000e+00 \
     ww=0.0000e+00     wwl=0.0000e+00     wln=1.0000e+00 \
    wwn=1.0000e+00 \
   tnom=2.7000e+01      at=3.3000e+04     ute=-1.760e+00 \
    kt1=-4.502e-01     kt2=2.2000e-02    kt1l=0.0000e+00 \
    ua1=0.0000e+00     ub1=0.0000e+00     uc1=0.0000e+00 \
    prt=0.0000e+00 \
   cgso=1.1667e-10    cgdo=1.1667e-10    cgbo=1.1000e-10 \
   cgdl=0.0000e+00    cgsl=0.0000e+00  ckappa=6.0000e-01 \
     cf=0.0000e+00     elm=5.0000e+00 \
  xpart=1.0000e+00     clc=1.0000e-15     cle=6.0000e-01 \
\
   rdsw=5.3040e+02 \
   cdsc=1.0000e-02   cdscb=0.0000e+00   cdscd=8.4480e-05 \
   prwb=0.0000e+00    prwg=0.0000e+00     cit=8.1220e-04 \
tox=1.5000e-08 \
  ngate=0.0000e+00 \
    nlx=1.5930e-07 \
     xl=-1.050e-06      xw=-5.000e-08 \
     af=1.3580e+00      kf=3.4460e-26      ef=1.0000e+00 \
   noia=1.7020e+20    noib=5.4630e+05    noic=-1.400e-11 \
     rd=0.0000e+00      rs=0.0000e+00     rsh=8.5000e+01 \
   minr=1.000e-03 \
    rdc=0.0000e+00     rsc=0.0000e+00 lint=8.9170e-08 \
wint=4.9380e-08   ldif=0.000e+00    hdif=6.0000e-07 \
     xj=3.0000e-07      js=5.1000e-07 \
      n=1.0000e+00 \
  dskip=no          tlev=0           tlevc=0         \
    jsw=6.0000e-13 \
     cj=1.0000e-04    cjsw=6.3750e-10 \
     fc=0.0000e+00    fcsw=0.000e+00 \
     mj=3.9000e-01    mjsw=2.7000e-01 \
     pb=5.3000e-01    pbsw=6.9000e-01     xti=2.0260e+00
ends modnmh
// ----------------------------------------------------------------------
// Owner: austriamicrosystems
// HIT-Kit: Digital
// ************************ SIMULATION PARAMETERS ************************
//  ----------------------------------------------------------------------
//  format    : Spectre (Spectre Direct)
//  model     : MOS BSIM3v3
//  process   : c35
//  revision  : 4.1;
//  extracted : Wafer B26654W01 2005/10/10 REVISION 4.0; wpc(5481)
//  doc#      : Eng-182  REV 6.0
//  ----------------------------------------------------------------------
//                        WORST CASE ZERO CONDITION
//  ----------------------------------------------------------------------
//  HV-TRANSISTOR
//  ----------------------------------------------------------------------
inline subckt modnmhl ( d g s b )
// Parameters: w l nrd nrs ad as pd ps
parameters w=1.0e-6 l=1.0e-6 nrd=0.0 nrs=0.0 ad=0.0 as=0.0 pd=0.0 ps=0.0 mult=1
+ ws=w
+ ls=l
+ dvthmat=mv_modnmhl*(0.95e-08/sqrt(ls*ws*mult)) dumat=mu_modnmhl*(3.5e-9/sqrt(ls*ws*mult))
//
if (modnmhl==1){
modnmhl ( d1 g s b ) mosinsub w=ws l=ls nrd=0 nrs=8.0000e-07/ws ad=ad as=as pd=pd ps=ps
rd ( d1 d ) resistor r=(2.1840e+03*4.0000e-06/(ws+(0.0000e+00))) tc1=6.2000e-03
}else
modnmhl ( d s ) resistor r=1e30
notvalid paramtest errorif=(modnmhl==0) \
message="
***************************************************
*
* nmosmhl is not valid in selected process option.
*
***************************************************"
//
model mosinsub bsim3v3 version=3.1 type=n  capmod=2.0000e+00 \
 mobmod=1.0000e+00  nqsmod=0.0000e+00  noimod=3 \
   vbox=1.000e+03      k1=7.4656e-01 \
     k2=7.9454e-02      k3=0.0000e+00     k3b=0.0000e+00 \
    nch=1.7070e+17 vth0=5.9500e-01+dvthmat \
   voff=-5.565e-02    dvt0=0.0000e+00    dvt1=1.6830e+00 \
   dvt2=4.1260e-02    keta=-8.210e-02 \
 pscbe1=4.0000e+10  pscbe2=1.0000e-10 \
 alpha0=0.0000e+00   beta0=3.0000e+01 \
  dvt0w=0.0000e+00   dvt1w=0.0000e+00   dvt2w=0.0000e+00 \
     ua=2.2380e-10      ub=0.0000e+00      uc=-1.429e-11 \
u0=4.0780e+02+(4.0780e+02)*dumat \
   dsub=5.0000e-01    eta0=1.6160e-03    etab=-1.373e-02 \
nfactor=8.5500e-01 \
     em=4.1000e+07    pclm=1.0550e-01 \
  drout=5.0000e-01 \
     a0=4.7540e-02      a1=0.0000e+00      a2=1.0000e+00 \
   pvag=0.0000e+00    vsat=5.2060e+04     ags=-3.227e-01      b0=0.0000e+00      b1=0.0000e+00 \
  delta=1.5850e-02 pdiblcb=3.8720e-01 \
pdiblc1=1.0000e-10 pdiblc2=1.0000e-10 \
     w0=0.0000e+00 \
    dlc=0.0000e+00 \
    dwc=0.0000e+00     dwb=0.0000e+00     dwg=0.0000e+00 \
     ll=0.0000e+00      lw=0.0000e+00     lwl=0.0000e+00 \
    lln=1.0000e+00     lwn=1.0000e+00      wl=0.0000e+00 \
     ww=0.0000e+00     wwl=0.0000e+00     wln=1.0000e+00 \
    wwn=1.0000e+00 \
     at=3.3000e+04     ute=-1.720e+00 \
    kt1=-4.202e-01     kt2=2.2000e-02    kt1l=0.0000e+00 \
    ua1=0.0000e+00     ub1=0.0000e+00     uc1=0.0000e+00 \
    prt=0.0000e+00 \
   cgso=1.1333e-10    cgdo=1.1333e-10    cgbo=1.1000e-10 \
   cgdl=0.0000e+00    cgsl=0.0000e+00  ckappa=6.0000e-01 \
     cf=0.0000e+00     elm=5.0000e+00 \
  xpart=1.0000e+00     clc=1.0000e-15     cle=6.0000e-01 \
\
   rdsw=5.3040e+02 \
   cdsc=0.0000e+00   cdscb=0.0000e+00   cdscd=0.0000e+00 \
   prwb=0.0000e+00    prwg=0.0000e+00     cit=2.9310e-05 \
tox=1.5400e-08 \
  ngate=0.0000e+00 \
    nlx=1.5930e-07 \
     xl=1.0000e-07      xw=0.0000e+00 \
     af=1.4000e+00      kf=3.7700e-26      ef=1.0000e+00 \
   noia=1.5360e+20    noib=3.5840e+05    noic=-1.304e-11 \
     rd=0.0000e+00      rs=0.0000e+00     rsh=7.5000e+01 \
   minr=1.000e-03 \
    rdc=0.0000e+00     rsc=0.0000e+00 lint=6.0000e-07 \
wint=0.0000e+00   ldif=0.000e+00    hdif=8.0000e-07 \
     xj=3.0000e-07      js=5.1000e-07 \
      n=1.0000e+00 \
  dskip=no          tlev=0           tlevc=0         \
    jsw=6.0000e-13 \
     cj=1.0380e-03    cjsw=3.1250e-10 \
     fc=0.0000e+00    fcsw=0.000e+00 \
     mj=3.4000e-01    mjsw=2.3000e-01 \
     pb=6.9000e-01    pbsw=6.9000e-01     xti=2.0300e+00
ends modnmhl
// ----------------------------------------------------------------------
// Owner: austriamicrosystems
// HIT-Kit: Digital
// ************************ SIMULATION PARAMETERS ************************
//  ----------------------------------------------------------------------
//  format    : Spectre (Spectre Direct)
//  model     : MOS BSIM3v3
//  process   : C35
//  revision  : 4.1;
//  extracted : C35 B11004.L2; 2002-11; hhl(5481)
//  doc#      : Eng-182  REV_6.0
//  ----------------------------------------------------------------------
//                        WORST CASE ZERO CONDITION
//  ----------------------------------------------------------------------
//  HV-TRANSISTOR
//  ----------------------------------------------------------------------
inline subckt modnh ( d g s b )
// Parameters: w l nrd nrs ad as pd ps
parameters w=1.0e-6 l=1.0e-6 nrd=0.0 nrs=0.0 ad=0.0 as=0.0 pd=0.0 ps=0.0 mult=1
+ ws=w
+ ls=l
+ dvthmat=mv_modnh*(0.67e-08/sqrt(ls*ws*mult)) dumat=mu_modnh*(4.9e-9/sqrt(ls*ws*mult))
//
if (modnh==1){
modnh ( d1 g s b ) mosinsub w=ws l=ls nrd=0 nrs=6.0000e-07/ws ad=ad as=as pd=pd ps=ps
rd ( d1 d ) resistor r=(1.6600e+03*4.0000e-06/(ws)) tc1=6.2000e-03
}else
modnh ( d s ) resistor r=1e30
notvalid paramtest errorif=(modnh==0) \
message="
***************************************************
*
* nmosh is not valid in selected process option.
*
***************************************************"
//
model mosinsub bsim3v3 version=3.1 type=n  capmod=2.0000e+00 \
 mobmod=1.0000e+00  nqsmod=0.0000e+00  noimod=3 \
   vbox=1.000e+03      k1=7.3212e-01 \
     k2=-1.732e-02      k3=-2.240e+00     k3b=6.9540e-01 \
    nch=2.7130e+17 vth0=5.3600e-01+dvthmat \
   voff=-5.090e-02    dvt0=4.9850e+01    dvt1=1.2960e+00 \
   dvt2=1.3110e-02    keta=-4.553e-02 \
 pscbe1=1.0000e+10  pscbe2=1.0240e-05 \
 alpha0=0.0000e+00   beta0=3.0000e+01 \
  dvt0w=0.0000e+00   dvt1w=0.0000e+00   dvt2w=0.0000e+00 \
     ua=1.0000e-30      ub=1.9490e-18      uc=1.2170e-10 \
u0=3.3870e+02+(3.3870e+02)*dumat \
   dsub=5.0000e-01    eta0=3.0750e-02    etab=-5.261e-02 \
nfactor=2.0340e-01 \
     em=4.1000e+07    pclm=2.9400e-01 \
  drout=5.0000e-01 \
     a0=1.8930e-01      a1=0.0000e+00      a2=1.0000e+00 \
   pvag=0.0000e+00    vsat=2.4020e+05     ags=1.2450e-01      b0=6.7900e-08      b1=0.0000e+00 \
  delta=1.7290e-02 pdiblcb=2.0670e-01 \
pdiblc1=3.0900e-02 pdiblc2=6.3750e-04 \
     w0=1.1450e-07 \
    dlc=6.0000e-07 \
    dwc=2.6050e-08     dwb=0.0000e+00     dwg=0.0000e+00 \
     ll=0.0000e+00      lw=0.0000e+00     lwl=0.0000e+00 \
    lln=1.0000e+00     lwn=1.0000e+00      wl=0.0000e+00 \
     ww=0.0000e+00     wwl=0.0000e+00     wln=1.0000e+00 \
    wwn=1.0000e+00 \
   tnom=2.7000e+01      at=3.3000e+04     ute=-1.800e+00 \
    kt1=-3.302e-01     kt2=2.2000e-02    kt1l=0.0000e+00 \
    ua1=0.0000e+00     ub1=0.0000e+00     uc1=0.0000e+00 \
    prt=0.0000e+00 \
   cgso=1.2933e-10    cgdo=1.2933e-10    cgbo=1.1000e-10 \
   cgdl=0.0000e+00    cgsl=0.0000e+00  ckappa=6.0000e-01 \
     cf=0.0000e+00     elm=5.0000e+00 \
  xpart=1.0000e+00     clc=1.0000e-15     cle=6.0000e-01 \
\
   rdsw=1.0920e+03 \
   cdsc=7.9440e-03   cdscb=0.0000e+00   cdscd=8.4480e-05 \
   prwb=0.0000e+00    prwg=0.0000e+00     cit=1.0000e-03 \
tox=7.6000e-09 \
  ngate=0.0000e+00 \
    nlx=1.1320e-07 \
     xl=0.0000e+00      xw=-5.000e-08 \
     af=1.3580e+00      kf=3.4460e-26      ef=1.0000e+00 \
   noia=1.7020e+20    noib=5.4630e+05    noic=-1.400e-11 \
     rd=0.0000e+00      rs=0.0000e+00     rsh=8.5000e+01 \
   minr=1.000e-03 \
    rdc=0.0000e+00     rsc=0.0000e+00 lint=6.0000e-07 \
wint=2.6050e-08   ldif=0.000e+00    hdif=6.0000e-07 \
     xj=3.0000e-07      js=5.1000e-07 \
      n=1.0000e+00 \
  dskip=no          tlev=0           tlevc=0         \
    jsw=6.0000e-13 \
     cj=1.0000e-04    cjsw=6.3750e-10 \
     fc=0.0000e+00    fcsw=0.000e+00 \
     mj=3.9000e-01    mjsw=2.7000e-01 \
     pb=5.3000e-01    pbsw=6.9000e-01     xti=2.0260e+00
ends modnh
// ----------------------------------------------------------------------
// Owner: austriamicrosystems
// HIT-Kit: Digital
// ************************ SIMULATION PARAMETERS ************************
//  ----------------------------------------------------------------------
//  format    : Spectre (Spectre Direct)
//  model     : MOS BSIM3v3
//  process   : c35
//  revision  : 4.0;
//  extracted : Wafer B26654W01 2005/10/05 REVISION 4.0; wpc(5481)
//  doc#      : Eng-182  REV 6.0
//  ----------------------------------------------------------------------
//                        WORST CASE ZERO CONDITION
//  ----------------------------------------------------------------------
//  HV-TRANSISTOR
//  ----------------------------------------------------------------------
inline subckt modnhl ( d g s b )
// Parameters: w l nrd nrs ad as pd ps
parameters w=1.0e-6 l=1.0e-6 nrd=0.0 nrs=0.0 ad=0.0 as=0.0 pd=0.0 ps=0.0 mult=1
+ ws=w
+ ls=l
+ dvthmat=mv_modnhl*(0.67e-08/sqrt(ls*ws*mult)) dumat=mu_modnhl*(4.9e-9/sqrt(ls*ws*mult))
//
if (modnhl==1){
modnhl ( d1 g s b ) mosinsub w=ws l=ls nrd=0 nrs=8.0000e-07/ws ad=ad as=as pd=pd ps=ps
rd ( d1 d ) resistor r=(1.7600e+03*4.0000e-06/(ws+(0.0000e+00))) tc1=6.2000e-03
}else
modnhl ( d s ) resistor r=1e30
notvalid paramtest errorif=(modnhl==0) \
message="
***************************************************
*
* nmoshl is not valid in selected process option.
*
***************************************************"
//
model mosinsub bsim3v3 version=3.1 type=n  capmod=2.0000e+00 \
 mobmod=1.0000e+00  nqsmod=0.0000e+00  noimod=3 \
   vbox=1.000e+03      k1=5.5197e-01 \
     k2=3.1858e-03      k3=0.0000e+00     k3b=0.0000e+00 \
    nch=1.9900e+17 vth0=4.6560e-01+dvthmat \
   voff=-5.119e-02    dvt0=0.0000e+00    dvt1=1.2960e+00 \
   dvt2=1.3110e-02    keta=-3.955e-02 \
 pscbe1=1.0000e+10  pscbe2=1.0240e-05 \
 alpha0=0.0000e+00   beta0=3.0000e+01 \
  dvt0w=0.0000e+00   dvt1w=0.0000e+00   dvt2w=0.0000e+00 \
     ua=1.0000e-30      ub=1.9490e-18      uc=1.2170e-10 \
u0=3.1630e+02+(3.1630e+02)*dumat \
   dsub=5.0000e-01    eta0=0.0000e+00    etab=0.0000e+00 \
nfactor=1.1530e+00 \
     em=4.1000e+07    pclm=2.9400e-01 \
  drout=5.0000e-01 \
     a0=3.3100e-01      a1=0.0000e+00      a2=1.0000e+00 \
   pvag=0.0000e+00    vsat=2.4020e+06     ags=3.2310e-01      b0=0.0000e+00      b1=0.0000e+00 \
  delta=3.1850e-02 pdiblcb=2.0670e-04 \
pdiblc1=3.0900e-02 pdiblc2=6.3750e-04 \
     w0=1.1450e-07 \
    dlc=0.0000e+00 \
    dwc=0.0000e+00     dwb=0.0000e+00     dwg=0.0000e+00 \
     ll=0.0000e+00      lw=0.0000e+00     lwl=0.0000e+00 \
    lln=1.0000e+00     lwn=1.0000e+00      wl=0.0000e+00 \
     ww=0.0000e+00     wwl=0.0000e+00     wln=1.0000e+00 \
    wwn=1.0000e+00 \
     at=3.3000e+04     ute=-1.700e+00 \
    kt1=-3.001e-01     kt2=2.2000e-02    kt1l=0.0000e+00 \
    ua1=0.0000e+00     ub1=0.0000e+00     uc1=0.0000e+00 \
    prt=0.0000e+00 \
   cgso=1.2933e-10    cgdo=1.2933e-10    cgbo=1.1000e-10 \
   cgdl=0.0000e+00    cgsl=0.0000e+00  ckappa=6.0000e-01 \
     cf=0.0000e+00     elm=5.0000e+00 \
  xpart=1.0000e+00     clc=1.0000e-15     cle=6.0000e-01 \
\
   rdsw=1.0920e+03 \
   cdsc=0.0000e+00   cdscb=0.0000e+00   cdscd=0.0000e+00 \
   prwb=0.0000e+00    prwg=0.0000e+00     cit=-2.050e-04 \
tox=7.6000e-09 \
  ngate=0.0000e+00 \
    nlx=1.1320e-07 \
     xl=2.5000e-07      xw=0.0000e+00 \
     af=1.4000e+00      kf=3.7700e-26      ef=1.0000e+00 \
   noia=1.5360e+20    noib=3.5840e+05    noic=-1.304e-11 \
     rd=0.0000e+00      rs=0.0000e+00     rsh=7.5000e+01 \
   minr=1.000e-03 \
    rdc=0.0000e+00     rsc=0.0000e+00 lint=6.0000e-07 \
wint=0.0000e+00   ldif=0.000e+00    hdif=8.0000e-07 \
     xj=3.0000e-07      js=5.1000e-07 \
      n=1.0000e+00 \
  dskip=no          tlev=0           tlevc=0         \
    jsw=6.0000e-13 \
     cj=1.0380e-03    cjsw=3.1250e-10 \
     fc=0.0000e+00    fcsw=0.000e+00 \
     mj=3.4000e-01    mjsw=2.3000e-01 \
     pb=6.9000e-01    pbsw=6.9000e-01     xti=2.0300e+00
ends modnhl
// ----------------------------------------------------------------------
// Owner: austriamicrosystems
// HIT-Kit: Digital
// ************************ SIMULATION PARAMETERS ************************
//  ----------------------------------------------------------------------
//  format    : Spectre (Spectre Direct)
//  model     : MOS BSIM3v3
//  process   : c35
//  revision  : ;
//  extracted : B58737.W09PE6; 2008-06; kmo(5966)
//  doc#      : ENG-327 Rev.2.0
//  ----------------------------------------------------------------------
//                        WORST CASE ZERO CONDITION
//  ----------------------------------------------------------------------
//  HV-TRANSISTOR
//  ----------------------------------------------------------------------
inline subckt modn30m ( d g s b )
// Parameters: w l nrd nrs ad as pd ps
parameters w=1.0e-6 l=1.0e-6 nrd=0.0 nrs=0.0 ad=0.0 as=0.0 pd=0.0 ps=0.0 mult=1 gv=(7.6860e-08/l + 9.1600e-01) dcdc=1
+ dvthmat=mv_modn30m*(0.56e-08/sqrt(l*w*mult)) dumat=mu_modn30m*(2.9e-9/sqrt(l*w*mult))
if (modn30m==1){
//
modn30m ( d1 g s1 b ) mosinsub w=w l=l nrd=0 nrs=8.0000e-07/w ad=0 as=as pd=0 ps=ps
rd ( d1 d ) resistor r=(1.1020e+00/(w+(1.6670e-06))) tc1=6.0000e-03
xj1 ( d gj d1 ) modn30mjfet1 w=w
xj2 ( d gj d1 ) modn30mjfet2 w=w
e1 ( d1 gj d1 s ) vcvs gain=gv min=-25 max=25
cgdx ( g d ) capacitor c=(4.0517e-10*w)
v1 ( s1 s ) vsource dc=0 type=dc
i1 ( d b ) bsource i=((6.1450e-10)/(l+(0.0000e+00))+(6.1590e-03))*i("v1:p")*(max((v(d,g)+(1.8290e-02)),1e-15))**(4.1480e+00)*exp((-1.4550e+01)/max((v(d,g)+(1.8290e-02)),1e-10))*(w+0.0000e+00)/w/(1+2.8000e+04*exp(7.7390e-03*i("v1:p")/(w+0.0000e+00)))
xdw ( b d1 ) modn30mnwd area=(1e-06*2.35*(w+1e-06*16)) perimeter=(4e-06*2.35+(w+1e-06*16))
}else
modn30m ( d s ) resistor r=1e30
notvalid paramtest errorif=(modn30m==0) \
message="
***************************************************
*
* nmos30m is not valid in selected process option.
*
***************************************************"
//
model mosinsub bsim3v3 version=3.1 type=n  capmod=2.0000e+00 \
 mobmod=1.0000e+00  nqsmod=0.0000e+00  noimod=3.0000e+00 \
   vbox=1.000e+03      k1=9.5734e-01 \
     k2=7.3760e-02      k3=2.3030e-01     k3b=-1.516e-02 \
    nch=2.5610e+17 vth0=8.0770e-01+dvthmat \
   voff=-6.529e-02    dvt0=1.1390e-03    dvt1=1.0310e-01 \
   dvt2=-1.601e-01    keta=-1.236e-02 \
 pscbe1=3.5770e+12  pscbe2=5.7730e-12 \
 alpha0=0.0000e+00   beta0=3.0000e+01 \
  dvt0w=3.0490e-01   dvt1w=2.3530e+05   dvt2w=-2.685e+00 \
     ua=5.6220e-12      ub=9.5730e-19      uc=7.1200e-13 \
u0=3.7000e+02+(3.7000e+02)*dumat \
   dsub=5.2500e+00    eta0=1.0000e-07    etab=-3.000e-01 \
nfactor=9.0620e-01 \
     em=4.1000e+07    pclm=2.8550e+00 \
  drout=5.0000e-01 \
     a0=8.2080e-01      a1=0.0000e+00      a2=1.0000e+00 \
   pvag=0.0000e+00    vsat=8.9380e+04     ags=1.8620e-02      b0=3.0590e-09      b1=2.6720e-02 \
  delta=3.7770e-05 pdiblcb=1.0000e-12 \
pdiblc1=5.1750e-04 pdiblc2=3.7770e-07 \
     w0=-4.630e-06 \
    dlc=-7.500e-07 \
    dwc=2.7390e-07     dwb=0.0000e+00     dwg=0.0000e+00 \
     ll=0.0000e+00      lw=0.0000e+00     lwl=0.0000e+00 \
    lln=1.0000e+00     lwn=1.0000e+00      wl=0.0000e+00 \
     ww=0.0000e+00     wwl=0.0000e+00     wln=1.0000e+00 \
    wwn=1.0000e+00 \
     at=3.3000e+04     ute=-1.710e+00 \
    kt1=-4.600e-01     kt2=2.2000e-02    kt1l=0.0000e+00 \
    ua1=0.0000e+00     ub1=0.0000e+00     uc1=0.0000e+00 \
    prt=0.0000e+00 \
   cgso=1.2138e-10    cgdo=1.0000e-15    cgbo=1.1000e-10 \
   cgdl=5.0000e-10    cgsl=4.8800e-10  ckappa=1.9890e+00 \
     cf=0.0000e+00     elm=5.0000e+00 \
  xpart=5.0000e-01     clc=1.0000e-15     cle=6.0000e-01 \
\
   rdsw=0.0000e+00 \
   cdsc=1.9360e-06   cdscb=1.0000e-12   cdscd=1.0740e-08 \
   prwb=0.0000e+00    prwg=0.0000e+00     cit=1.0740e-06 \
tox=1.5000e-08 \
  ngate=0.0000e+00 \
    nlx=2.6040e-07 \
     xl=0.0000e+00      xw=0.0000e+00 \
     af=1.9886e+00      kf=1.6086e-24      ef=1.0000e+00 \
   noia=2.5794e+19    noib=1.0199e+05    noic=-2.372e-12 \
     rd=0.0000e+00      rs=0.0000e+00     rsh=7.5000e+01 \
   minr=1.000e-03 \
    rdc=0.0000e+00     rsc=0.0000e+00 lint=-2.271e-07 \
wint=2.7390e-07   ldif=0.000e+00    hdif=8.0000e-07 \
     xj=9.0000e-07      js=3.5530e-07 \
      n=1.0000e+00 \
  dskip=no          tlev=0           tlevc=0         \
    jsw=1.7560e-12 \
     cj=1.0500e-03    cjsw=3.1250e-10 \
     fc=0.0000e+00    fcsw=0.000e+00 \
     mj=3.4000e-01    mjsw=2.3000e-01 \
     pb=6.9000e-01    pbsw=6.9000e-01     xti=2.0260e+00
ends modn30m
// HV-jfet 1
inline subckt modn30mjfet1 (d b s)
parameters w=1e-6
modn30mjfet1 (d b s) rnjfetinsub
model rnjfetinsub jfet type=n \
beta=3.9830e+00/(1+(2.8000e-03)*(temp-(2.7000e+01)))*(w+(1.6670e-06))/(1+(6.0000e-03)*(temp-27)) \
vto=-5.700e+00*(1+(2.8000e-03)*(temp-(2.7000e+01))) \
lambda=0.0000e+00 \
is=0.0000e+00  pb=5.0000e-01 \
cgs=0.0000e+00 rs=0.0000e+00 \
cgd=0.0000e+00 rd=0.0000e+00
ends modn30mjfet1
// HV-jfet 2
inline subckt  modn30mjfet2 (d b s)
parameters w=1e-6
modn30mjfet2 (d b s) rnjfetinsub
model rnjfetinsub jfet type=n \
beta=4.0450e+00/(1+(2.8000e-03)*(temp-(2.7000e+01)))*(w+(1.6670e-06))/(1+(6.0000e-03)*(temp-27)) \
vto=-7.957e+00*(1+(2.8000e-03)*(temp-(2.7000e+01))) \
lambda=0.0000e+00 \
is=0.0000e+00  pb=5.0000e-01 \
cgs=0.0000e+00 rs=0.0000e+00 \
cgd=0.0000e+00 rd=0.0000e+00
ends modn30mjfet2
//

inline subckt modn30mnwd ( a c )
parameters area=1.0e-12 perimeter=1.0e-6
modn30mnwd ( a c ) diodeinsub area=area perim=perimeter region=off
model diodeinsub diode level=1 dskip=no \
is=1.676e-06          isw=2.158e-11                n=1.000e+00 ns=1.000e+00 \
minr=0.100e+00   imax=(1.000e+00/area) \
cj0=8.798e-05        m=2.737e-01                  vj=5.300e-01 tt=0.000e+00 \
cjsw=6.611e-10       mjsw=2.122e-01             vjsw=5.300e-01 fc=0.000e+00\
af=1.000e+00     kf=0.000e+00            xti=1.366e+00
ends modn30mnwd
// ----------------------------------------------------------------------
// Owner: austriamicrosystems
// HIT-Kit: Digital
// ************************ SIMULATION PARAMETERS ************************
//  ----------------------------------------------------------------------
//  format    : Spectre (Spectre Direct)
//  model     : MOS BSIM3v3
//  process   : c35
//  revision  : ;
//  extracted : B58737.W09PE6; 2008-06; kmo(5966)
//  doc#      : ENG-327 Rev.2.0
//  ----------------------------------------------------------------------
//                        WORST CASE ZERO CONDITION
//  ----------------------------------------------------------------------
//  HV-TRANSISTOR
//  ----------------------------------------------------------------------
inline subckt modn18t ( d g s b )
// Parameters: w l nrd nrs ad as pd ps
parameters w=1.0e-6 l=1.0e-6 nrd=0.0 nrs=0.0 ad=0.0 as=0.0 pd=0.0 ps=0.0 mult=1 gv=(2.8290e-07/l + 8.9230e-01) dcdc=1
+ dvthmat=mv_modn18t*(0.78e-08/sqrt(l*w*mult)) dumat=mu_modn18t*(6.9e-09/sqrt(l*w*mult))
if (modn18t==1){
//
modn18t ( d1 g s1 b ) mosinsub w=w l=l nrd=0 nrs=8.0000e-07/w ad=0 as=as pd=0 ps=ps
rd ( d1 d ) resistor r=(1.1350e+00/(w+(2.4730e-06))) tc1=5.0000e-03
xj1 ( d gj d1 ) modn18tjfet1 w=w
xj2 ( d gj d1 ) modn18tjfet2 w=w
e1 ( d1 gj d1 s ) vcvs gain=gv min=-25 max=25
cgdx ( g d ) capacitor c=(4.9867e-10*w)
v1 ( s1 s ) vsource dc=0 type=dc
i1 ( d b ) bsource i=((5.3850e-10)/(l+(0.0000e+00))+(4.8260e-03))*i("v1:p")*(max((v(d,g)+(2.9600e-02)),1e-15))**(3.8580e+00)*exp((-4.2900e+00)/max((v(d,g)+(2.9600e-02)),1e-10))*(w+0.0000e+00)/w/(1+3.3810e+04*exp(5.3330e-03*i("v1:p")/(w+0.0000e+00)))
xdw ( b d1 ) modn18tnwd area=(1e-06*2.35*(w+1e-06*16)) perimeter=(4e-06*2.35+(w+1e-06*16))
}else
modn18t ( d s ) resistor r=1e30
notvalid paramtest errorif=(modn18t==0) \
message="
***************************************************
*
* nmos18t is not valid in selected process option.
*
***************************************************"
//
model mosinsub bsim3v3 version=3.1 type=n  capmod=2.0000e+00 \
 mobmod=1.0000e+00  nqsmod=0.0000e+00  noimod=3.0000e+00 \
   vbox=1.000e+03      k1=6.6854e-01 \
     k2=-3.914e-03      k3=-2.570e+00     k3b=1.9850e+00 \
    nch=2.6530e+17 vth0=5.4760e-01+dvthmat \
   voff=-8.829e-02    dvt0=1.8190e-01    dvt1=1.0200e-01 \
   dvt2=-5.409e-02    keta=-3.582e-02 \
 pscbe1=3.5770e+12  pscbe2=5.7730e-12 \
 alpha0=0.0000e+00   beta0=3.0000e+01 \
  dvt0w=7.9230e-01   dvt1w=6.0330e+05   dvt2w=-2.792e+00 \
     ua=2.1750e-10      ub=4.8850e-19      uc=1.2070e-10 \
u0=3.3700e+02+(3.3700e+02)*dumat \
   dsub=5.2500e+00    eta0=1.0000e-07    etab=-3.000e-01 \
nfactor=8.6770e-01 \
     em=4.1000e+07    pclm=6.0510e+00 \
  drout=5.0000e-01 \
     a0=7.6440e-01      a1=0.0000e+00      a2=1.0000e+00 \
   pvag=0.0000e+00    vsat=5.5760e+04     ags=2.3440e-01      b0=4.4050e-09      b1=2.6720e-02 \
  delta=2.5490e-05 pdiblcb=1.0000e-12 \
pdiblc1=2.2650e+00 pdiblc2=1.0000e-09 \
     w0=-7.990e-01 \
    dlc=-1.040e-06 \
    dwc=1.6680e-07     dwb=0.0000e+00     dwg=0.0000e+00 \
     ll=0.0000e+00      lw=0.0000e+00     lwl=0.0000e+00 \
    lln=1.0000e+00     lwn=1.0000e+00      wl=0.0000e+00 \
     ww=0.0000e+00     wwl=0.0000e+00     wln=1.0000e+00 \
    wwn=1.0000e+00 \
     at=3.3000e+04     ute=-1.720e+00 \
    kt1=-3.210e-01     kt2=2.2000e-02    kt1l=0.0000e+00 \
    ua1=0.0000e+00     ub1=0.0000e+00     uc1=0.0000e+00 \
    prt=0.0000e+00 \
   cgso=1.3317e-10    cgdo=1.0000e-15    cgbo=1.1000e-10 \
   cgdl=4.4020e-10    cgsl=5.0000e-10  ckappa=6.2280e-01 \
     cf=0.0000e+00     elm=5.0000e+00 \
  xpart=5.0000e-01     clc=1.0000e-15     cle=6.0000e-01 \
\
   rdsw=0.0000e+00 \
   cdsc=5.0330e-20   cdscb=2.9060e-04   cdscd=7.3780e-10 \
   prwb=0.0000e+00    prwg=0.0000e+00     cit=7.3780e-08 \
tox=7.6000e-09 \
  ngate=0.0000e+00 \
    nlx=1.4630e-07 \
     xl=0.0000e+00      xw=0.0000e+00 \
     af=2.0045e+00      kf=8.5977e-25      ef=1.0000e+00 \
   noia=4.8618e+18    noib=2.9560e+04    noic=-2.148e-13 \
     rd=0.0000e+00      rs=0.0000e+00     rsh=7.5000e+01 \
   minr=1.000e-03 \
    rdc=0.0000e+00     rsc=0.0000e+00 lint=-3.414e-07 \
wint=1.6680e-07   ldif=0.000e+00    hdif=8.0000e-07 \
     xj=9.0000e-07      js=3.5530e-07 \
      n=1.0000e+00 \
  dskip=no          tlev=0           tlevc=0         \
    jsw=1.7560e-12 \
     cj=1.0500e-03    cjsw=3.1250e-10 \
     fc=0.0000e+00    fcsw=0.000e+00 \
     mj=3.4000e-01    mjsw=2.3000e-01 \
     pb=6.9000e-01    pbsw=6.9000e-01     xti=2.0260e+00
ends modn18t
// HV-jfet 1
inline subckt modn18tjfet1 (d b s)
parameters w=1e-6
modn18tjfet1 (d b s) rnjfetinsub
model rnjfetinsub jfet type=n \
beta=3.5710e+00/(1+(1.6000e-03)*(temp-(2.7000e+01)))*(w+(2.4730e-06))/(1+(5.0000e-03)*(temp-27)) \
vto=-7.402e+00*(1+(1.6000e-03)*(temp-(2.7000e+01))) \
lambda=0.0000e+00 \
is=0.0000e+00  pb=5.0000e-01 \
cgs=0.0000e+00 rs=0.0000e+00 \
cgd=0.0000e+00 rd=0.0000e+00
ends modn18tjfet1
// HV-jfet 2
inline subckt  modn18tjfet2 (d b s)
parameters w=1e-6
modn18tjfet2 (d b s) rnjfetinsub
model rnjfetinsub jfet type=n \
beta=1.7520e+00/(1+(1.6000e-03)*(temp-(2.7000e+01)))*(w+(2.4730e-06))/(1+(5.0000e-03)*(temp-27)) \
vto=-7.947e+00*(1+(1.6000e-03)*(temp-(2.7000e+01))) \
lambda=0.0000e+00 \
is=0.0000e+00  pb=5.0000e-01 \
cgs=0.0000e+00 rs=0.0000e+00 \
cgd=0.0000e+00 rd=0.0000e+00
ends modn18tjfet2
//

inline subckt modn18tnwd ( a c )
parameters area=1.0e-12 perimeter=1.0e-6
modn18tnwd ( a c ) diodeinsub area=area perim=perimeter region=off
model diodeinsub diode level=1 dskip=no \
is=2.159e-06          isw=3.227e-11                n=1.000e+00 ns=1.000e+00 \
minr=0.100e+00   imax=(1.000e+00/area) \
cj0=8.992e-05        m=2.671e-01                  vj=5.300e-01 tt=0.000e+00 \
cjsw=6.406e-10       mjsw=2.161e-01             vjsw=5.300e-01 fc=0.000e+00\
af=1.000e+00     kf=0.000e+00            xti=4.786e-01
ends modn18tnwd

// ----------------------------------------------------------------------
// Owner: austriamicrosystems
// HIT-Kit: Digital
// ************************ SIMULATION PARAMETERS ************************
//  ----------------------------------------------------------------------
//  format    : Spectre (Spectre Direct)
//  model     : MOS HiSIM_HV
//  process   : c35
//  revision  : REVISION 3.0 Wafer C50118W01 2013/12/12;
//  extracted : MCT;
//  doc#      : Eng-327 REV 5.0
//  ----------------------------------------------------------------------
//                        WORST CASE ZERO CONDITION
//  ----------------------------------------------------------------------
//
// UNSYMMETRIC HV-TRANSISTOR WITH EXTENDED PARASITICS
// PARAMS: NRD NRS AD AS PD PS AW PW (SEE NETLIST FORMAT DOC.)
// NMOS: N-Well Diode
// PMOS: P-Well Diode + PSUB+Diode
//  ----------------------------------------------------------------------
inline subckt modpd30m ( d g s b psub )
// Parameters: w l nrd nrs ad as pd ps
parameters w=1.0e-6 l=1.0e-6 nrd=0.0 nrs=0.0 ad=0.0 as=0.0 pd=0.0 ps=0.0 mult=1 dtemp=0
+ isoVoltage=50
+ dvthmat=(mv_modpd30m)*(1.73e-08/sqrt(l*w*mult)) dumat=(mu_modpd30m)*(6.15e-09/sqrt(l*w*mult))
if (modpd30m==1){
modpd30m ( d g s b ) mosinsub w=w l=l nrd=0 nrs=8.0000e-07/w ad=0 as=as pd=0 ps=ps
xpd ( d b ) modpd30mpd area=w*3.7e-06 perimeter=3.7e-06*2*mult
xnwd ( psub b ) modpd30mnwd area=(w+1e-06*23.6)*(l+1e-06*8.25) perimeter=4*(l+1e-06*8.25)+(w+1e-06*23.6)
}else
modpd30m ( d s ) resistor r=1e30
notvalid paramtest errorif=(modpd30m==0) \
message="
***************************************************
*
* pmosd30m is not valid in selected process option.
*
***************************************************"
//
model mosinsub hisim_hv version=1.230e+00 type=p \
 corsrd=3.0000e+00  coovlp=1.0000e+00 coovlps=1.0000e+00 \
 coisub=0.0000e+00  coiigs=0.0000e+00  cogidl=0.0000e+00 \
 coisti=0.0000e+00  coadov=1.0000e+00   conqs=0.0000e+00 \
   corg=0.0000e+00 corbnet=0.0000e+00 coflick=1.0000e+00 \
cothrml=1.0000e+00   coign=0.0000e+00  coiprv=1 \
  codfm=0.0000e+00 coselfheat=1.0000e+00   cosym=0.0000e+00  \
cosubnode=0.0000e+00  cotemp=0.0000e+00 coldrift=1.0000e+00 \
coqovsm=1.0000e+00  shemax=5.0000e+02  copprv=1.0000e+00
***************************************************************************
*                             Extension to LDMOS                          *
***************************************************************************
+loverld=1.0000e-08   lover=4.9860e-08 ldrift1=1.0000e-06 \
ldrift2=1.0000e-06  novers=1.8290e+17   nover=2.0600e+17
***************************************************************************
*                                   Charges                               *
***************************************************************************
+     xl=0.0000e+00      xw=5.3321e-11     xld=0.0000e+00 \
  xldld=-3.000e-07     xwd=1.6634e-06    xwdc=0.0000e+00   xwdld=0.0000e+00 \
     ll=0.0000e+00     lld=0.0000e+00     lln=0.0000e+00      wl=0.0000e+00 \
    wld=0.0000e+00     wln=0.0000e+00      vfbc=-4.717e-01+dvthmat \
    vbi=1.1000e+00      tox=1.5000e-08    ddltmax=2.4843e+00 \
ddltslp=0.0000e+00 ddltict=1.0000e+01   kappa=3.9000e+00
***************************************************************************
*                          Threshold Voltage Shift                        *
***************************************************************************
+  parl2=1.0000e-08      sc1=1.2113e+01     sc2=5.0000e-02 \
    sc3=0.0000e+00     sc4=0.0000e+00  pthrou=0.0000e+00 \
     nsubp=1.0520e+17      lp=1.3447e-07     bs1=0.0000e+00 \
    bs2=9.0000e-01    scp1=1.5395e+00    scp2=1.0000e-01 \
   scp3=0.0000e+00   scp21=0.0000e+00   scp22=0.0000e+00 \
  npext=1.0000e+17   lpext=1.0000e-50
***************************************************************************
*                   Depletion Effect of the Gate Poly-Si                  *
***************************************************************************
+   pgd1=0.0000e+00    pgd2=1.0000e+00    pgd3=8.0000e-01 \
   pgd4=0.0000e+00
***************************************************************************
*                       Quantum Mechanical Effects                        *
***************************************************************************
+   qme1=0.0000e+00    qme2=1.0000e+00    qme3=0.0000e+00
***************************************************************************
*                            Mobility Model                               *
***************************************************************************
+muecb0=1.0000e+02*(1+dumat)     muecb1=7.5427e+01*(1+dumat) mueph0=3.0000e-01 \
mueph1=8.7775e+03*(1+dumat) muephl=1.1341e+00  mueplp=1.0000e+00 \
 muesr0=2.2790e+00      muesr1=8.6146e+15*(1+dumat) muesrl=-1.087e-01 \
 mueslp=1.0000e+00    ndep=1.0000e+00   ndepl=0.0000e+00 \
 ndeplp=1.0000e+00    ninv=5.0000e-01   ninvd=0.0000e+00 \
     bb=1.0000e+00     vmax=6.4148e+06 \
  vover=3.2667e+00 \
 voverp=2.0000e+00
***************************************************************************
*                        Channel Length Modulation                        *
***************************************************************************
+   clm1=5.0000e-01    clm2=4.0000e+00    clm3=1.0000e+00 \
   clm5=1.0000e+00    clm6=0.0000e+00
***************************************************************************
*                          Narrow Channel Effects                         *
***************************************************************************
+    wfc=0.0000e+00   wvth0=-2.159e-01     nsubc=4.3775e+16 \
 nsubcw=0.0000e+00 nsubcwp=1.0000e+00  nsubp0=0.0000e+00 \
 nsubwp=1.0000e+00  muephw=4.5673e+00  muepwp=1.0000e+00 \
 muesrw=7.8626e-02  mueswp=1.0000e+00  vthsti=0.0000e+00 \
  vdsti=0.0000e+00  scsti1=0.0000e+00  scsti2=0.0000e+00 \
   nsti=1.0000e+17    wsti=0.0000e+00   wstil=0.0000e+00 \
 wstilp=1.0000e+00   wstiw=0.0000e+00  wstiwp=1.0000e+00 \
    wl1=0.0000e+00    wl1p=1.0000e+00     wl2=-1.938e-01 \
   wl2p=1.0000e+00  muephs=-5.777e-01  muepsp=1.0000e+00 \
 vovers=-1.000e-01 voversp=0.0000e+00
***************************************************************************
*                          Source/Drain Diffusion                         *
***************************************************************************
+nsubpsti1=0.0000e+00 nsubpsti2=0.0000e+00 nsubpsti3=1.0000e+00 \
muesti1=0.0000e+00 muesti2=0.0000e+00 muesti3=1.0000e+00 \
  saref=1.0000e-06   sbref=1.0000e-06
***************************************************************************
*                         Temperature Dependencies                        *
***************************************************************************
+    eg0=1.1790e+00  bgtmp1=9.0255e-05  bgtmp2=-2.432e-07 \
 muetmp=1.2226e+00    tnom=2.7000e+01    vtmp=3.6866e-01 \
   egig=0.0000e+00 igtemp2=0.0000e+00 igtemp3=0.0000e+00 \
rdtemp1=3.4836e-04 rdtemp2=2.6548e-06 rdvdtemp1=-5.189e-04 \
rdvdtemp2=9.7855e-07
***************************************************************************
*                                Resistances                              *
***************************************************************************
    +rd=5.9271e-03      rs=0.0000e+00     rsh=0.0000e+00 \
   rshg=0.0000e+00    rbpb=5.0000e+01    rbpd=5.0000e+01 \
   rbps=5.0000e+01 \
 rdvg11=6.4018e+00  rdvg12=1.6108e+01     rdvd=1.2640e-02 \
   rdvb=7.4912e-02     rds=-7.748e-01    rdsp=1.0000e+00 \
  rdvdl=0.0000e+00   rdvds=-4.921e-01  rdvdsp=1.0000e+00 \
 rdov11=0.0000e+00  rdov12=1.0000e+00  rdov13=1.0000e+00 \
 rdslp1=0.0000e+00    rd20=0.0000e+00    rd21=1.0000e+00 \
   rd22=-1.312e-01   rd22d=0.0000e+00     rd23=3.7023e-01 \
  rd23l=5.6859e-01  rd23lp=1.0000e+00   rd23s=-1.675e+00 \
 rd23sp=1.0000e+00    rd24=0.0000e+00    rd25=0.0000e+00 \
  gbmin=1.0000e-12
***************************************************************************
*                                Capacitances                             *
***************************************************************************
+    xqy=0.0000e+00    xqy1=0.0000e+00    xqy2=2.0000e+00 \
vfbover=-1.000e+00   qovsm=2.0000e-01   ovslp=2.0000e-08 \
  ovmag=5.0000e+02    cgso=1.9203e-10    cgdo=3.5523e-10 \
   cgbo=1.1000e-10   tpoly=2.0000e-07
***************************************************************************
*                              Leakage Currents                           *
***************************************************************************
+   sub1=5.0000e-02   sub1l=2.5000e-03  sub1lp=1.0000e+00 \
   sub2=3.0048e+01   sub2l=2.0000e-06    svds=8.0000e-01 \
    slg=3.0000e-08    slgl=0.0000e+00   slglp=1.0000e+00 \
   svbs=5.0000e-01   svbsl=0.0000e+00  svbslp=1.0000e+00 \
   svgs=8.0000e-01   svgsl=0.0000e+00  svgslp=1.0000e+00 \
  svgsw=0.0000e+00  svgswp=1.0000e+00   ibpc1=0.0000e+00 \
  ibpc2=0.0000e+00  subld1=0.0000e+00  subld2=0.0000e+00 \
 gleak1=5.0000e+01  gleak2=1.0000e+07  gleak3=6.0000e-02 \
 gleak4=4.0000e+00  gleak5=7.5000e+03  gleak6=2.5000e-01 \
 gleak7=1.0000e-06   glkb1=5.0000e-16   glkb2=1.0000e+00 \
  glkb3=0.0000e+00  glksd1=1.0000e-15  glksd2=1.0000e-02 \
 glksd3=-1.000e-02 glpart1=5.0000e-01     fn1=0.0000e+00 \
    fn2=0.0000e+00     fn3=0.0000e+00    fvbs=0.0000e+00 \
  gidl1=2.0000e+00   gidl2=3.0000e+07   gidl3=9.0000e-01 \
  gidl4=9.0000e-01   gidl5=2.0000e-01
***************************************************************************
*                             S/B and D/B Diodes                          *
***************************************************************************
+    js0=3.0890e-07   js0sw=1.1310e-13      nj=1.0000e+00 \
   njsw=1.0000e+00     xti=3.8400e+00    xti2=3.8400e+00 \
   divx=0.0000e+00    cisb=0.0000e+00     cvb=0.0000e+00 \
  ctemp=0.0000e+00   cisbk=0.0000e+00    cvbk=0.0000e+00 \
     cj=1.5232e-03    cjsw=3.9200e-10   cjswg=3.5000e-10 \
     mj=5.4000e-01    mjsw=4.6000e-01   mjswg=4.6000e-01 \
     pb=1.0200e+00    pbsw=1.0200e+00   pbswg=1.0200e+00 \
 vdiffj=6.0000e-04
***************************************************************************
*                                   Noise                                 *
***************************************************************************
+  nftrp=3.2435e+07   nfalp=1.5485e-18     cit=0.0000e+00 \
  falph=1.0000e+00
***************************************************************************
*                           Non Quasi Static Model                        *
***************************************************************************
+   dly1=1.0000e-10    dly2=7.0000e-01    dly3=8.0000e-07 \
  dlyov=0.0000e+00
***************************************************************************
*                            Self heating Effect                          *
***************************************************************************
+   rth0=5.5684e-01    cth0=1.0000e-07   rth0w=-8.500e+00 \
 rth0wp=1.0000e+00  rth0nf=0.0000e+00
***************************************************************************
*                                   DFM                                   *
***************************************************************************
+ mphdfm=-3.000e-01
***************************************************************************
*                         Additional Node                                 *
***************************************************************************
+ pzadd0=5.0000e-03  vzadd0=1.0000e-02 \
 rdict1=1.0000e+00  rdict2=0.0000e+00  rdvdlp=1.0000e+00 \
 vbsmin=-1.050e+01  rdslp2=1.0000e+00
***************************************************************************
*                         Additional Node                                 *
***************************************************************************
+ rdvsub=3.0000e-01 rdvdsub=1.0000e+00  ddrift=1.0000e-06 \
 vbisub=7.0000e-01 nsubsub=1.0000e+15
ends modpd30m
//

inline subckt modpd30mpd ( a c )
parameters area=1.0e-12 perimeter=1.0e-6
modpd30mpd ( a c ) diodeinsub area=area perim=perimeter region=off
model diodeinsub diode level=1 dskip=no \
  is=6.1140e-07          isw=2.4910e-13 \
   n=1.0400e+00           ns=1.0400e+00 \
minr=0.100e+00          imax=(1.000e+00/area) \
 cj0=1.2340e-03           m=6.2660e-01 \
  vj=1.0200e+00           tt=0.000e+00 \
cjsw=2.8230e-10         mjsw=4.8760e-01 \
vjsw=1.0200e+00           fc=0.000e+00 \
  af=1.000e+00             kf=0.000e+00 \
 xti=2.7630e+00
ends modpd30mpd
//

inline subckt modpd30mnwd ( a c )
parameters area=1.0e-12 perimeter=1.0e-6
modpd30mnwd ( a c ) diodeinsub area=area perim=perimeter region=off
model diodeinsub diode level=1 dskip=no \
  is=7.101e-06          isw=5.386e-12 \
   n=1.000e+00      ns=1.000e+00 \
minr=0.100e+00    imax=(1.000e+00/area) \
 cj0=3.850e-04           m=2.982e-01 \
  vj=5.300e-01          vjsw=5.300e-01 \
  fc=0.000e+00        tt=0.000e+00 \
cjsw=0.000e+00       mjsw=4.401e-01 \
  af=1.000e+00     kf=0.000e+00 \
 xti=-3.138e+00
ends modpd30mnwd

// ----------------------------------------------------------------------
// Owner: austriamicrosystems
// HIT-Kit: Digital
// ************************ SIMULATION PARAMETERS ************************
//  ----------------------------------------------------------------------
//  format    : Spectre (Spectre Direct)
//  model     : MOS HiSIM_HV
//  process   : c35
//  revision  : REVISION 1.0 Wafer C50118W01 2013/12/12;
//  extracted : MCT;
//  doc#      : Eng-327 REV 5.0
//  ----------------------------------------------------------------------
//                        WORST CASE ZERO CONDITION
//  ----------------------------------------------------------------------
//
// UNSYMMETRIC HV-TRANSISTOR WITH EXTENDED PARASITICS
// PARAMS: NRD NRS AD AS PD PS AW PW (SEE NETLIST FORMAT DOC.)
// NMOS: N-Well Diode
// PMOS: P-Well Diode + PSUB+Diode
//  ----------------------------------------------------------------------
inline subckt modp30m ( d g s b psub )
// Parameters: w l nrd nrs ad as pd ps
parameters w=1.0e-6 l=1.0e-6 nrd=0.0 nrs=0.0 ad=0.0 as=0.0 pd=0.0 ps=0.0 mult=1 dtemp=0
+ isoVoltage=50
+ dvthmat=(mv_modp30m)*(1.73e-08/sqrt(l*w*mult)) dumat=(mu_modp30m)*(6.15e-09/sqrt(l*w*mult))
if (modp30m==1){
modp30m ( d g s b ) mosinsub w=w l=l nrd=0 nrs=8.0000e-07/w ad=0 as=as pd=0 ps=ps
xpd ( d b ) modp30mpd area=w*3.7e-06 perimeter=3.7e-06*2*mult
xnwd ( psub b ) modp30mnwd area=(w+1e-06*23.6)*(l+1e-06*8.25) perimeter=4*(l+1e-06*8.25)+(w+1e-06*23.6)
}else
modp30m ( d s ) resistor r=1e30
notvalid paramtest errorif=(modp30m==0) \
message="
***************************************************
*
* pmosd30m is not valid in selected process option.
*
***************************************************"
//
model mosinsub hisim_hv version=1.230e+00 type=p \
 corsrd=3.0000e+00  coovlp=1.0000e+00 coovlps=1.0000e+00 \
 coisub=0.0000e+00  coiigs=0.0000e+00  cogidl=0.0000e+00 \
 coisti=0.0000e+00  coadov=1.0000e+00   conqs=0.0000e+00 \
   corg=0.0000e+00 corbnet=0.0000e+00 coflick=1.0000e+00 \
cothrml=1.0000e+00   coign=0.0000e+00  coiprv=1 \
  codfm=0.0000e+00 coselfheat=1.0000e+00   cosym=0.0000e+00  \
cosubnode=0.0000e+00  cotemp=0.0000e+00 coldrift=1.0000e+00 \
coqovsm=1.0000e+00  shemax=5.0000e+02  copprv=1.0000e+00
***************************************************************************
*                             Extension to LDMOS                          *
***************************************************************************
+loverld=1.0000e-08   lover=4.9860e-08 ldrift1=1.0000e-06 \
ldrift2=1.0000e-06  novers=1.8290e+17   nover=2.0600e+17
***************************************************************************
*                                   Charges                               *
***************************************************************************
+     xl=0.0000e+00      xw=5.3321e-11     xld=0.0000e+00 \
  xldld=-3.000e-07     xwd=1.6634e-06    xwdc=0.0000e+00   xwdld=0.0000e+00 \
     ll=0.0000e+00     lld=0.0000e+00     lln=0.0000e+00      wl=0.0000e+00 \
    wld=0.0000e+00     wln=0.0000e+00      vfbc=-4.717e-01+dvthmat \
    vbi=1.1000e+00      tox=1.5000e-08    ddltmax=2.4843e+00 \
ddltslp=0.0000e+00 ddltict=1.0000e+01   kappa=3.9000e+00
***************************************************************************
*                          Threshold Voltage Shift                        *
***************************************************************************
+  parl2=1.0000e-08      sc1=1.2113e+01     sc2=5.0000e-02 \
    sc3=0.0000e+00     sc4=0.0000e+00  pthrou=0.0000e+00 \
     nsubp=1.0520e+17      lp=1.3447e-07     bs1=0.0000e+00 \
    bs2=9.0000e-01    scp1=1.5395e+00    scp2=1.0000e-01 \
   scp3=0.0000e+00   scp21=0.0000e+00   scp22=0.0000e+00 \
  npext=1.0000e+17   lpext=1.0000e-50
***************************************************************************
*                   Depletion Effect of the Gate Poly-Si                  *
***************************************************************************
+   pgd1=0.0000e+00    pgd2=1.0000e+00    pgd3=8.0000e-01 \
   pgd4=0.0000e+00
***************************************************************************
*                       Quantum Mechanical Effects                        *
***************************************************************************
+   qme1=0.0000e+00    qme2=1.0000e+00    qme3=0.0000e+00
***************************************************************************
*                            Mobility Model                               *
***************************************************************************
+muecb0=1.0000e+02*(1+dumat)     muecb1=7.5427e+01*(1+dumat) mueph0=3.0000e-01 \
mueph1=8.7775e+03*(1+dumat) muephl=1.1341e+00  mueplp=1.0000e+00 \
 muesr0=2.2790e+00      muesr1=8.6146e+15*(1+dumat) muesrl=-1.087e-01 \
 mueslp=1.0000e+00    ndep=1.0000e+00   ndepl=0.0000e+00 \
 ndeplp=1.0000e+00    ninv=5.0000e-01   ninvd=0.0000e+00 \
     bb=1.0000e+00     vmax=6.4148e+06 \
  vover=3.2667e+00 \
 voverp=2.0000e+00
***************************************************************************
*                        Channel Length Modulation                        *
***************************************************************************
+   clm1=5.0000e-01    clm2=4.0000e+00    clm3=1.0000e+00 \
   clm5=1.0000e+00    clm6=0.0000e+00
***************************************************************************
*                          Narrow Channel Effects                         *
***************************************************************************
+    wfc=0.0000e+00   wvth0=-2.159e-01     nsubc=4.3775e+16 \
 nsubcw=0.0000e+00 nsubcwp=1.0000e+00  nsubp0=0.0000e+00 \
 nsubwp=1.0000e+00  muephw=4.5673e+00  muepwp=1.0000e+00 \
 muesrw=7.8626e-02  mueswp=1.0000e+00  vthsti=0.0000e+00 \
  vdsti=0.0000e+00  scsti1=0.0000e+00  scsti2=0.0000e+00 \
   nsti=1.0000e+17    wsti=0.0000e+00   wstil=0.0000e+00 \
 wstilp=1.0000e+00   wstiw=0.0000e+00  wstiwp=1.0000e+00 \
    wl1=0.0000e+00    wl1p=1.0000e+00     wl2=-1.938e-01 \
   wl2p=1.0000e+00  muephs=-5.777e-01  muepsp=1.0000e+00 \
 vovers=-1.000e-01 voversp=0.0000e+00
***************************************************************************
*                          Source/Drain Diffusion                         *
***************************************************************************
+nsubpsti1=0.0000e+00 nsubpsti2=0.0000e+00 nsubpsti3=1.0000e+00 \
muesti1=0.0000e+00 muesti2=0.0000e+00 muesti3=1.0000e+00 \
  saref=1.0000e-06   sbref=1.0000e-06
***************************************************************************
*                         Temperature Dependencies                        *
***************************************************************************
+    eg0=1.1790e+00  bgtmp1=9.0255e-05  bgtmp2=-2.432e-07 \
 muetmp=1.2226e+00    tnom=2.7000e+01    vtmp=3.6866e-01 \
   egig=0.0000e+00 igtemp2=0.0000e+00 igtemp3=0.0000e+00 \
rdtemp1=3.4836e-04 rdtemp2=2.6548e-06 rdvdtemp1=-5.189e-04 \
rdvdtemp2=9.7855e-07
***************************************************************************
*                                Resistances                              *
***************************************************************************
    +rd=5.9271e-03      rs=0.0000e+00     rsh=0.0000e+00 \
   rshg=0.0000e+00    rbpb=5.0000e+01    rbpd=5.0000e+01 \
   rbps=5.0000e+01 \
 rdvg11=6.4018e+00  rdvg12=1.6108e+01     rdvd=1.2640e-02 \
   rdvb=7.4912e-02     rds=-7.748e-01    rdsp=1.0000e+00 \
  rdvdl=0.0000e+00   rdvds=-4.921e-01  rdvdsp=1.0000e+00 \
 rdov11=0.0000e+00  rdov12=1.0000e+00  rdov13=1.0000e+00 \
 rdslp1=0.0000e+00    rd20=0.0000e+00    rd21=1.0000e+00 \
   rd22=-1.312e-01   rd22d=0.0000e+00     rd23=3.7023e-01 \
  rd23l=5.6859e-01  rd23lp=1.0000e+00   rd23s=-1.675e+00 \
 rd23sp=1.0000e+00    rd24=0.0000e+00    rd25=0.0000e+00 \
  gbmin=1.0000e-12
***************************************************************************
*                                Capacitances                             *
***************************************************************************
+    xqy=0.0000e+00    xqy1=0.0000e+00    xqy2=2.0000e+00 \
vfbover=-1.000e+00   qovsm=2.0000e-01   ovslp=2.0000e-08 \
  ovmag=5.0000e+02    cgso=1.9203e-10    cgdo=3.5523e-10 \
   cgbo=1.1000e-10   tpoly=2.0000e-07
***************************************************************************
*                              Leakage Currents                           *
***************************************************************************
+   sub1=5.0000e-02   sub1l=2.5000e-03  sub1lp=1.0000e+00 \
   sub2=3.0048e+01   sub2l=2.0000e-06    svds=8.0000e-01 \
    slg=3.0000e-08    slgl=0.0000e+00   slglp=1.0000e+00 \
   svbs=5.0000e-01   svbsl=0.0000e+00  svbslp=1.0000e+00 \
   svgs=8.0000e-01   svgsl=0.0000e+00  svgslp=1.0000e+00 \
  svgsw=0.0000e+00  svgswp=1.0000e+00   ibpc1=0.0000e+00 \
  ibpc2=0.0000e+00  subld1=0.0000e+00  subld2=0.0000e+00 \
 gleak1=5.0000e+01  gleak2=1.0000e+07  gleak3=6.0000e-02 \
 gleak4=4.0000e+00  gleak5=7.5000e+03  gleak6=2.5000e-01 \
 gleak7=1.0000e-06   glkb1=5.0000e-16   glkb2=1.0000e+00 \
  glkb3=0.0000e+00  glksd1=1.0000e-15  glksd2=1.0000e-02 \
 glksd3=-1.000e-02 glpart1=5.0000e-01     fn1=0.0000e+00 \
    fn2=0.0000e+00     fn3=0.0000e+00    fvbs=0.0000e+00 \
  gidl1=2.0000e+00   gidl2=3.0000e+07   gidl3=9.0000e-01 \
  gidl4=9.0000e-01   gidl5=2.0000e-01
***************************************************************************
*                             S/B and D/B Diodes                          *
***************************************************************************
+    js0=3.0890e-07   js0sw=1.1310e-13      nj=1.0000e+00 \
   njsw=1.0000e+00     xti=3.8400e+00    xti2=3.8400e+00 \
   divx=0.0000e+00    cisb=0.0000e+00     cvb=0.0000e+00 \
  ctemp=0.0000e+00   cisbk=0.0000e+00    cvbk=0.0000e+00 \
     cj=1.5232e-03    cjsw=3.9200e-10   cjswg=3.5000e-10 \
     mj=5.4000e-01    mjsw=4.6000e-01   mjswg=4.6000e-01 \
     pb=1.0200e+00    pbsw=1.0200e+00   pbswg=1.0200e+00 \
 vdiffj=6.0000e-04
***************************************************************************
*                                   Noise                                 *
***************************************************************************
+  nftrp=3.2435e+07   nfalp=1.5485e-18     cit=0.0000e+00 \
  falph=1.0000e+00
***************************************************************************
*                           Non Quasi Static Model                        *
***************************************************************************
+   dly1=1.0000e-10    dly2=7.0000e-01    dly3=8.0000e-07 \
  dlyov=0.0000e+00
***************************************************************************
*                            Self heating Effect                          *
***************************************************************************
+   rth0=5.5684e-01    cth0=1.0000e-07   rth0w=-8.500e+00 \
 rth0wp=1.0000e+00  rth0nf=0.0000e+00
***************************************************************************
*                                   DFM                                   *
***************************************************************************
+ mphdfm=-3.000e-01
***************************************************************************
*                         Additional Node                                 *
***************************************************************************
+ pzadd0=5.0000e-03  vzadd0=1.0000e-02 \
 rdict1=1.0000e+00  rdict2=0.0000e+00  rdvdlp=1.0000e+00 \
 vbsmin=-1.050e+01  rdslp2=1.0000e+00
***************************************************************************
*                         Additional Node                                 *
***************************************************************************
+ rdvsub=3.0000e-01 rdvdsub=1.0000e+00  ddrift=1.0000e-06 \
 vbisub=7.0000e-01 nsubsub=1.0000e+15
ends modp30m
//

inline subckt modp30mpd ( a c )
parameters area=1.0e-12 perimeter=1.0e-6
modp30mpd ( a c ) diodeinsub area=area perim=perimeter region=off
model diodeinsub diode level=1 dskip=no \
  is=6.1140e-07          isw=2.4910e-13 \
   n=1.0400e+00           ns=1.0400e+00 \
minr=0.100e+00          imax=(1.000e+00/area) \
 cj0=1.2340e-03           m=6.2660e-01 \
  vj=1.0200e+00           tt=0.000e+00 \
cjsw=2.8230e-10         mjsw=4.8760e-01 \
vjsw=1.0200e+00           fc=0.000e+00 \
  af=1.000e+00             kf=0.000e+00 \
 xti=2.7630e+00
ends modp30mpd
//

inline subckt modp30mnwd ( a c )
parameters area=1.0e-12 perimeter=1.0e-6
modp30mnwd ( a c ) diodeinsub area=area perim=perimeter region=off
model diodeinsub diode level=1 dskip=no \
  is=7.101e-06          isw=5.386e-12 \
   n=1.000e+00      ns=1.000e+00 \
minr=0.100e+00    imax=(1.000e+00/area) \
 cj0=3.850e-04           m=2.982e-01 \
  vj=5.300e-01          vjsw=5.300e-01 \
  fc=0.000e+00        tt=0.000e+00 \
cjsw=0.000e+00       mjsw=4.401e-01 \
  af=1.000e+00     kf=0.000e+00 \
 xti=-3.138e+00
ends modp30mnwd

// ----------------------------------------------------------------------
// Owner: austriamicrosystems
// HIT-Kit: Digital
// ************************ SIMULATION PARAMETERS ************************
//  ----------------------------------------------------------------------
//  format    : Spectre (Spectre Direct)
//  model     : MOS BSIM3v3
//  process   : C35
//  revision  : 1.0;
//  extracted : C18069; 28.08.2011; bse (5866)
//  doc#      : Eng-?? REV_0
//  ----------------------------------------------------------------------
//                         WORST CASE ZERO CONDITION
//
//  ----------------------------------------------------------------------
//
inline subckt nmosw_2n ( d g s b )
parameters w=1.0e-6 l=1.0e-6 nrd=0.0 nrs=0.0 ad=0.0 as=0.0 pd=0.0 ps=0.0 ng=1
+ ws= w
+ ls= l
+ shk=1
+ dvthmat=(mv_nmosw_2n)*(0.67e-08/sqrt(ls*ws*ng)) dumat=(mu_nmosw_2n)*(4.9e-9/sqrt(ls*ws*ng))
//
if (modn==1)
nmosw_2n ( d g s b ) mosinsub w=ws l=ls nrd=8.0000e-07/ws nrs=8.0000e-07/ws ad=ad as=as pd=pd ps=ps m=ng
else
nmosw_2n ( d s ) resistor r=1e30
notvalid paramtest errorif=(modn==0) \
message="
***************************************************
*
* nmos is not valid in selected process option.
*
***************************************************"
model mosinsub bsim3v3 version=3.2400e+00  type=n  capmod=3.0000e+00 \
 mobmod=1.0000e+00  nqsmod=0.0000e+00  noimod=3.0000e+00 \
   vbox=1.000e+03      k1=4.6580e-01 \
     k2=0.0000e+00      k3=3.0270e-02     k3b=-1.089e-02 \
    nch=2.4200e+17 vth0=5.4780e-01+dvthmat \
   voff=-7.600e-02    dvt0=2.1160e+01    dvt1=1.0640e+00 \
   dvt2=3.0590e-02    keta=-1.200e-02 \
 pscbe1=1.0000e+30  pscbe2=1.0000e-06 \
 alpha0=1.9040e-06  alpha1=2.5000e+00   beta0=2.0000e+01 \
  dvt0w=2.0000e+00   dvt1w=1.6970e+06   dvt2w=-1.556e-02 \
     ua=-3.981e-10      ub=2.6890e-18      uc=6.9180e-11 \
u0=4.1460e+02+(4.1460e+02)*dumat \
   dsub=5.0000e-01    eta0=1.4790e-02    etab=-5.280e-02 \
nfactor=2.6780e-01 \
     em=4.1000e+07    pclm=9.6570e-01 \
  drout=5.0000e-01 \
     a0=2.0840e+00      a1=0.0000e+00      a2=1.0000e+00 \
   pvag=1.3460e-01    vsat=1.0200e+05     ags=3.6080e-01      b0=5.0200e-08      b1=1.0060e-07 \
  delta=2.3500e-03 pdiblcb=3.2150e-01 \
pdiblc1=1.0800e-01 pdiblc2=1.6220e-03 \
     w0=-3.185e-07 \
    dlc=-1.588e-08 \
dwc=-3.263e-01*l+1.5050e-07    dwb=0.0000e+00     dwg=-9.302e-09 \
     ll=1.0680e-13      lw=0.0000e+00     lwl=0.0000e+00 \
    lln=1.0000e+00     lwn=1.0000e+00      wl=2.8610e-13 \
     ww=-1.130e-14     wwl=-9.411e-21     wln=1.0000e+00 \
     wr=1.0000e+00     wwn=1.0000e+00 \
     at=2.5000e+04     ute=-1.700e+00 \
    kt1=-3.100e-01     kt2=-1.720e-02    kt1l=0.0000e+00 \
    ua1=0.0000e+00     ub1=0.0000e+00     uc1=0.0000e+00 \
    prt=3.0000e+01 \
   cgso=1.0850e-12    cgdo=1.0850e-12    cgbo=1.7000e-08 \
   cgdl=3.0810e-10    cgsl=3.0810e-10  ckappa=2.6020e+00 \
     cf=0.0000e+00     elm=5.0000e+00 \
  xpart=1.0000e+00     clc=1.0000e-15     cle=6.0000e-01 \
\
   rdsw=1.1390e+03 \
   cdsc=0.0000e+00   cdscb=1.5000e-09   cdscd=0.0000e+00 \
   prwb=-5.000e-02    prwg=1.3340e-02     cit=8.0260e-04 \
tox=7.6700e-09 \
  ngate=1.0000e+00 \
    nlx=1.7000e-07 \
     xl=7.2040e-08      xw=0.0000e+00 \
     af=1.3760e+00      kf=3.3960e-26      ef=1.0000e+00 \
   noia=1.3990e+20    noib=2.7070e+05    noic=-4.680e-12 \
     rd=0.0000e+00      rs=0.0000e+00     rsh=8.5000e+01 \
   minr=1.000e-03 \
    rdc=0.0000e+00     rsc=0.0000e+00 lint=-3.098e-07 \
wint=-8.969e-07   ldif=0.000e+00    hdif=8.0000e-07 \
     xj=3.0000e-07      js=5.1000e-07 \
      n=1.0000e+00 \
  dskip=no          tlev=0           tlevc=0         \
    jsw=6.0000e-13 \
     cj=1.0380e-03    cjsw=3.1250e-10 \
     fc=0.0000e+00    fcsw=0.000e+00 \
     mj=3.4000e-01    mjsw=2.3000e-01 \
     pb=6.9000e-01    pbsw=6.9000e-01     xti=2.0300e+00
ends nmosw_2n

// ----------------------------------------------------------------------

// ----------------------------------------------------------------------
// Owner: austriamicrosystems
// HIT-Kit: Digital
// ************************ SIMULATION PARAMETERS ************************
//  ----------------------------------------------------------------------
//  format    : Spectre (Spectre Direct)
//  model     : MOS BSIM3v3
//  process   : C35
//  revision  : 1.0;
//  extracted : C18069; 28.08.2011; bse (5866)
//  doc#      : Eng-?? REV_0
//  ----------------------------------------------------------------------
//                         WORST CASE ZERO CONDITION
//
//  ----------------------------------------------------------------------
//
inline subckt nmosw_3n ( d g s b )
parameters w=1.0e-6 l=1.0e-6 nrd=0.0 nrs=0.0 ad=0.0 as=0.0 pd=0.0 ps=0.0 ng=1
+ ws= w
+ ls= l
+ shk=1
+ dvthmat=(mv_nmosw_3n)*(0.67e-08/sqrt(ls*ws*ng)) dumat=(mu_nmosw_3n)*(4.9e-9/sqrt(ls*ws*ng))
//
if (modn==1)
nmosw_3n ( d g s b ) mosinsub w=ws l=ls nrd=8.0000e-07/ws nrs=8.0000e-07/ws ad=ad as=as pd=pd ps=ps m=ng
else
nmosw_3n ( d s ) resistor r=1e30
notvalid paramtest errorif=(modn==0) \
message="
***************************************************
*
* nmos is not valid in selected process option.
*
***************************************************"
model mosinsub bsim3v3 version=3.2400e+00  type=n  capmod=3.0000e+00 \
 mobmod=1.0000e+00  nqsmod=0.0000e+00  noimod=3.0000e+00 \
   vbox=1.000e+03      k1=4.6580e-01 \
     k2=0.0000e+00      k3=3.0270e-02     k3b=-1.089e-02 \
    nch=2.4200e+17 vth0=5.4780e-01+dvthmat \
   voff=-7.600e-02    dvt0=2.1160e+01    dvt1=1.0640e+00 \
   dvt2=3.0590e-02    keta=-1.200e-02 \
 pscbe1=1.0000e+30  pscbe2=1.0000e-06 \
 alpha0=1.9040e-06  alpha1=2.5000e+00   beta0=2.0000e+01 \
  dvt0w=2.0000e+00   dvt1w=1.6970e+06   dvt2w=-1.556e-02 \
     ua=-3.981e-10      ub=2.6890e-18      uc=6.9180e-11 \
u0=4.1460e+02+(4.1460e+02)*dumat \
   dsub=5.0000e-01    eta0=1.4790e-02    etab=-5.280e-02 \
nfactor=2.6780e-01 \
     em=4.1000e+07    pclm=9.6570e-01 \
  drout=5.0000e-01 \
     a0=2.0840e+00      a1=0.0000e+00      a2=1.0000e+00 \
   pvag=1.3460e-01    vsat=1.0200e+05     ags=3.6080e-01      b0=5.0200e-08      b1=1.0060e-07 \
  delta=2.3500e-03 pdiblcb=3.2150e-01 \
pdiblc1=2.3600e-01 pdiblc2=2.4880e-03 \
     w0=-3.185e-07 \
    dlc=-1.588e-08 \
dwc=-3.263e-01*l+1.5050e-07    dwb=0.0000e+00     dwg=-9.302e-09 \
     ll=1.0680e-13      lw=0.0000e+00     lwl=0.0000e+00 \
    lln=1.0000e+00     lwn=1.0000e+00      wl=2.8610e-13 \
     ww=-1.130e-14     wwl=-9.411e-21     wln=1.0000e+00 \
     wr=1.0000e+00     wwn=1.0000e+00 \
     at=2.5000e+04     ute=-1.700e+00 \
    kt1=-3.100e-01     kt2=-1.720e-02    kt1l=0.0000e+00 \
    ua1=0.0000e+00     ub1=0.0000e+00     uc1=0.0000e+00 \
    prt=3.0000e+01 \
   cgso=1.0850e-12    cgdo=1.0850e-12    cgbo=1.7000e-08 \
   cgdl=3.0810e-10    cgsl=3.0810e-10  ckappa=2.6020e+00 \
     cf=0.0000e+00     elm=5.0000e+00 \
  xpart=1.0000e+00     clc=1.0000e-15     cle=6.0000e-01 \
\
   rdsw=1.1390e+03 \
   cdsc=0.0000e+00   cdscb=1.5000e-09   cdscd=0.0000e+00 \
   prwb=-1.471e-01    prwg=1.3340e-02     cit=8.0260e-04 \
tox=7.6700e-09 \
  ngate=1.0000e+00 \
    nlx=1.7000e-07 \
     xl=6.8040e-08      xw=0.0000e+00 \
     af=1.3760e+00      kf=3.3960e-26      ef=1.0000e+00 \
   noia=1.3990e+20    noib=2.7070e+05    noic=-4.680e-12 \
     rd=0.0000e+00      rs=0.0000e+00     rsh=8.5000e+01 \
   minr=1.000e-03 \
    rdc=0.0000e+00     rsc=0.0000e+00 lint=-3.098e-07 \
wint=-8.216e-07   ldif=0.000e+00    hdif=8.0000e-07 \
     xj=3.0000e-07      js=5.1000e-07 \
      n=1.0000e+00 \
  dskip=no          tlev=0           tlevc=0         \
    jsw=6.0000e-13 \
     cj=1.0380e-03    cjsw=3.1250e-10 \
     fc=0.0000e+00    fcsw=0.000e+00 \
     mj=3.4000e-01    mjsw=2.3000e-01 \
     pb=6.9000e-01    pbsw=6.9000e-01     xti=2.0300e+00
ends nmosw_3n

// ----------------------------------------------------------------------

// ----------------------------------------------------------------------
// Owner: austriamicrosystems
// HIT-Kit: Digital
// ************************ SIMULATION PARAMETERS ************************
//  ----------------------------------------------------------------------
//  format    : Spectre (Spectre Direct)
//  model     : MOS BSIM3v3
//  process   : C35
//  revision  : 1.0;
//  extracted : C18069; 28.08.2011; bse (5866)
//  doc#      : Eng-?? REV_0
//  ----------------------------------------------------------------------
//                         WORST CASE ZERO CONDITION
//
//  ----------------------------------------------------------------------
//
inline subckt nmosw_4n ( d g s b )
parameters w=1.0e-6 l=1.0e-6 nrd=0.0 nrs=0.0 ad=0.0 as=0.0 pd=0.0 ps=0.0 ng=1
+ ws= w
+ ls= l
+ shk=1
+ dvthmat=(mv_nmosw_4n)*(0.67e-08/sqrt(ls*ws*ng)) dumat=(mu_nmosw_4n)*(4.9e-9/sqrt(ls*ws*ng))
//
if (modn==1)
nmosw_4n ( d g s b ) mosinsub w=ws l=ls nrd=8.0000e-07/ws nrs=8.0000e-07/ws ad=ad as=as pd=pd ps=ps m=ng
else
nmosw_4n ( d s ) resistor r=1e30
notvalid paramtest errorif=(modn==0) \
message="
***************************************************
*
* nmos is not valid in selected process option.
*
***************************************************"
model mosinsub bsim3v3 version=3.2400e+00  type=n  capmod=3.0000e+00 \
 mobmod=1.0000e+00  nqsmod=0.0000e+00  noimod=3.0000e+00 \
   vbox=1.000e+03      k1=4.6580e-01 \
     k2=0.0000e+00      k3=3.0270e-02     k3b=-1.089e-02 \
    nch=2.4200e+17 vth0=5.4780e-01+dvthmat \
   voff=-7.600e-02    dvt0=2.1160e+01    dvt1=1.0640e+00 \
   dvt2=3.0590e-02    keta=-1.200e-02 \
 pscbe1=1.0000e+30  pscbe2=1.0000e-06 \
 alpha0=1.9040e-06  alpha1=2.5000e+00   beta0=2.0000e+01 \
  dvt0w=2.0000e+00   dvt1w=1.6970e+06   dvt2w=-1.556e-02 \
     ua=-3.981e-10      ub=2.5120e-18      uc=6.9180e-11 \
u0=4.1460e+02+(4.1460e+02)*dumat \
   dsub=5.0000e-01    eta0=1.4790e-02    etab=-5.280e-02 \
nfactor=2.6780e-01 \
     em=4.1000e+07    pclm=9.6570e-01 \
  drout=5.0000e-01 \
     a0=2.0840e+00      a1=0.0000e+00      a2=1.0000e+00 \
   pvag=1.3460e-01    vsat=1.0200e+05     ags=3.1620e-01      b0=5.0200e-08      b1=1.0060e-07 \
  delta=2.3500e-03 pdiblcb=3.2150e-01 \
pdiblc1=8.3400e-01 pdiblc2=2.4880e-03 \
     w0=-3.185e-07 \
    dlc=-1.588e-08 \
dwc=-3.263e-01*l+1.5050e-07    dwb=0.0000e+00     dwg=-9.302e-09 \
     ll=0.0000e+00      lw=0.0000e+00     lwl=0.0000e+00 \
    lln=1.0000e+00     lwn=1.0000e+00      wl=-1.924e-13 \
     ww=0.0000e+00     wwl=0.0000e+00     wln=1.0000e+00 \
     wr=1.0000e+00     wwn=1.0000e+00 \
     at=2.5000e+04     ute=-1.700e+00 \
    kt1=-3.100e-01     kt2=-1.720e-02    kt1l=0.0000e+00 \
    ua1=0.0000e+00     ub1=0.0000e+00     uc1=0.0000e+00 \
    prt=-2.456e+02 \
   cgso=1.0850e-12    cgdo=1.0850e-12    cgbo=1.7000e-08 \
   cgdl=3.0810e-10    cgsl=3.0810e-10  ckappa=2.6020e+00 \
     cf=0.0000e+00     elm=5.0000e+00 \
  xpart=1.0000e+00     clc=1.0000e-15     cle=6.0000e-01 \
\
   rdsw=1.1410e+03 \
   cdsc=0.0000e+00   cdscb=1.5000e-09   cdscd=0.0000e+00 \
   prwb=-7.244e-02    prwg=1.1740e-01     cit=8.0260e-04 \
tox=7.6700e-09 \
  ngate=1.0000e+00 \
    nlx=1.7000e-07 \
     xl=8.0100e-08      xw=0.0000e+00 \
     af=1.3760e+00      kf=3.3960e-26      ef=1.0000e+00 \
   noia=1.3990e+20    noib=2.7070e+05    noic=-4.680e-12 \
     rd=0.0000e+00      rs=0.0000e+00     rsh=8.5000e+01 \
   minr=1.000e-03 \
    rdc=0.0000e+00     rsc=0.0000e+00 lint=-1.868e-07 \
wint=-3.544e-07   ldif=0.000e+00    hdif=8.0000e-07 \
     xj=3.0000e-07      js=5.1000e-07 \
      n=1.0000e+00 \
  dskip=no          tlev=0           tlevc=0         \
    jsw=6.0000e-13 \
     cj=1.0380e-03    cjsw=3.1250e-10 \
     fc=0.0000e+00    fcsw=0.000e+00 \
     mj=3.4000e-01    mjsw=2.3000e-01 \
     pb=6.9000e-01    pbsw=6.9000e-01     xti=2.0300e+00
ends nmosw_4n

// ----------------------------------------------------------------------

// ----------------------------------------------------------------------
// Owner: austriamicrosystems
// HIT-Kit: Digital
// ************************ SIMULATION PARAMETERS ************************
//  ----------------------------------------------------------------------
//  format    : Spectre (Spectre Direct)
//  model     : MOS BSIM3v3
//  process   : C35
//  revision  : 1.0;
//  extracted : C18069; 28.08.2011; bse (5866)
//  doc#      : Eng-?? REV_0
//  ----------------------------------------------------------------------
//                         WORST CASE ZERO CONDITION
//
//  ----------------------------------------------------------------------
//
inline subckt nmosmw_2n ( d g s b )
parameters w=1.0e-6 l=1.0e-6 nrd=0.0 nrs=0.0 ad=0.0 as=0.0 pd=0.0 ps=0.0 ng=1
+ ws= w
+ ls= l
+ shk=1
+ dvthmat=(mv_nmosmw_2n)*(1.03e-08/sqrt(ls*ws*ng)) dumat=(mu_nmosmw_2n)*(3.5e-9/sqrt(ls*ws*ng))
//
if (modnm==1)
nmosmw_2n ( d g s b ) mosinsub w=ws l=ls nrd=6.0000e-07/ws nrs=6.0000e-07/ws ad=ad as=as pd=pd ps=ps m=ng
else
nmosmw_2n ( d s ) resistor r=1e30
notvalid paramtest errorif=(modnm==0) \
message="
***************************************************
*
* nmosm is not valid in selected process option.
*
***************************************************"
model mosinsub bsim3v3 version=3.2400e+00  type=n  capmod=3.0000e+00 \
 mobmod=1.0000e+00  nqsmod=0.0000e+00  noimod=3.0000e+00 \
   vbox=1.000e+03      k1=8.4760e-01 \
     k2=0.0000e+00      k3=-2.500e+00     k3b=-5.640e-02 \
    nch=1.5560e+17 vth0=8.2170e-01+dvthmat \
   voff=-9.684e-02    dvt0=2.0510e+01    dvt1=1.0610e+00 \
   dvt2=2.5970e-02    keta=3.2000e-02 \
 pscbe1=1.0000e+30  pscbe2=1.0000e-06 \
 alpha0=5.5350e-08  alpha1=1.3930e-01   beta0=1.9570e+01 \
  dvt0w=1.0800e+01   dvt1w=3.0990e+06   dvt2w=1.4520e-01 \
     ua=1.4200e-12      ub=1.7380e-18      uc=5.7540e-11 \
u0=4.3850e+02+(4.3850e+02)*dumat \
   dsub=5.0000e-01    eta0=4.0860e-02    etab=-1.000e-03 \
nfactor=8.6050e-01 \
     em=4.1000e+07    pclm=9.0000e-01 \
  drout=5.0000e-01 \
     a0=1.0000e+00      a1=0.0000e+00      a2=1.0000e+00 \
   pvag=6.0000e-02    vsat=5.3380e+04     ags=1.9140e-01      b0=2.0000e-08      b1=1.0000e-08 \
  delta=1.0000e-02 pdiblcb=9.7980e-01 \
pdiblc1=2.4800e-01 pdiblc2=1.2400e-03 \
     w0=3.3160e-08 \
    dlc=1.3960e-09 \
dwc=-2.884e-01*l+1.4740e-07    dwb=8.6800e-09     dwg=-3.770e-09 \
     ll=7.4510e-14      lw=0.0000e+00     lwl=0.0000e+00 \
    lln=1.0000e+00     lwn=1.0000e+00      wl=-3.626e-13 \
     ww=-1.514e-14     wwl=-1.321e-20     wln=1.0000e+00 \
     wr=1.0000e+00     wwn=1.0000e+00 \
     at=3.3000e+04     ute=-1.720e+00 \
    kt1=-4.180e-01     kt2=-4.560e-02    kt1l=0.0000e+00 \
    ua1=0.0000e+00     ub1=0.0000e+00     uc1=0.0000e+00 \
    prt=0.0000e+00 \
   cgso=1.0050e-10    cgdo=1.0050e-10    cgbo=1.6000e-08 \
   cgdl=1.0800e-10    cgsl=1.0800e-10  ckappa=2.9570e+00 \
     cf=0.0000e+00     elm=5.0000e+00 \
  xpart=1.0000e+00     clc=1.0000e-15     cle=6.0000e-01 \
\
   rdsw=3.0420e+03 \
   cdsc=0.0000e+00   cdscb=2.0000e-03   cdscd=0.0000e+00 \
   prwb=5.0000e-02    prwg=4.3480e-03     cit=0.0000e+00 \
tox=1.5000e-08 \
  ngate=1.0000e+00 \
    nlx=1.5690e-07 \
     xl=1.0010e-07      xw=0.0000e+00 \
     af=1.3580e+00      kf=3.4460e-26      ef=1.0000e+00 \
   noia=1.7020e+20    noib=5.4630e+05    noic=-1.400e-11 \
     rd=0.0000e+00      rs=0.0000e+00     rsh=8.9530e+01 \
   minr=1.000e-03 \
    rdc=0.0000e+00     rsc=0.0000e+00 lint=-3.093e-07 \
wint=-8.560e-07   ldif=0.000e+00    hdif=6.0000e-07 \
     xj=3.0000e-07      js=5.1000e-07 \
      n=1.0000e+00 \
  dskip=no          tlev=0           tlevc=0         \
    jsw=6.0000e-13 \
     cj=1.0380e-03    cjsw=3.1250e-10 \
     fc=0.0000e+00    fcsw=0.000e+00 \
     mj=3.4000e-01    mjsw=2.3000e-01 \
     pb=6.9000e-01    pbsw=6.9000e-01     xti=2.0300e+00
ends nmosmw_2n

// ----------------------------------------------------------------------

// ----------------------------------------------------------------------
// Owner: austriamicrosystems
// HIT-Kit: Digital
// ************************ SIMULATION PARAMETERS ************************
//  ----------------------------------------------------------------------
//  format    : Spectre (Spectre Direct)
//  model     : MOS BSIM3v3
//  process   : C35
//  revision  : 1.0;
//  extracted : C18069; 28.08.2011; bse (5866)
//  doc#      : Eng-?? REV_0
//  ----------------------------------------------------------------------
//                         WORST CASE ZERO CONDITION
//
//  ----------------------------------------------------------------------
//
inline subckt nmosmw_3n ( d g s b )
parameters w=1.0e-6 l=1.0e-6 nrd=0.0 nrs=0.0 ad=0.0 as=0.0 pd=0.0 ps=0.0 ng=1
+ ws= w
+ ls= l
+ shk=1
+ dvthmat=(mv_nmosmw_3n)*(1.03e-08/sqrt(ls*ws*ng)) dumat=(mu_nmosmw_3n)*(3.5e-9/sqrt(ls*ws*ng))
//
if (modnm==1)
nmosmw_3n ( d g s b ) mosinsub w=ws l=ls nrd=6.0000e-07/ws nrs=6.0000e-07/ws ad=ad as=as pd=pd ps=ps m=ng
else
nmosmw_3n ( d s ) resistor r=1e30
notvalid paramtest errorif=(modnm==0) \
message="
***************************************************
*
* nmosm is not valid in selected process option.
*
***************************************************"
model mosinsub bsim3v3 version=3.2400e+00  type=n  capmod=3.0000e+00 \
 mobmod=1.0000e+00  nqsmod=0.0000e+00  noimod=3.0000e+00 \
   vbox=1.000e+03      k1=8.4760e-01 \
     k2=0.0000e+00      k3=-2.500e+00     k3b=-5.640e-02 \
    nch=1.5560e+17 vth0=8.2170e-01+dvthmat \
   voff=-9.684e-02    dvt0=2.0510e+01    dvt1=1.0610e+00 \
   dvt2=2.5970e-02    keta=3.2000e-02 \
 pscbe1=1.0000e+30  pscbe2=1.0000e-06 \
 alpha0=5.5350e-08  alpha1=1.3930e-01   beta0=1.9570e+01 \
  dvt0w=1.0800e+01   dvt1w=3.0990e+06   dvt2w=1.4520e-01 \
     ua=1.4200e-12      ub=1.7380e-18      uc=5.7540e-11 \
u0=4.3850e+02+(4.3850e+02)*dumat \
   dsub=5.0000e-01    eta0=4.0860e-02    etab=-1.000e-03 \
nfactor=8.6050e-01 \
     em=4.1000e+07    pclm=9.0000e-01 \
  drout=5.0000e-01 \
     a0=1.0000e+00      a1=0.0000e+00      a2=1.0000e+00 \
   pvag=6.0000e-02    vsat=6.1710e+04     ags=1.9140e-01      b0=2.0000e-08      b1=1.0000e-08 \
  delta=1.0000e-02 pdiblcb=9.7980e-01 \
pdiblc1=1.4000e-01 pdiblc2=1.3490e-03 \
     w0=3.3160e-08 \
    dlc=1.3960e-09 \
dwc=-2.884e-01*l+1.4740e-07    dwb=8.6800e-09     dwg=-3.770e-09 \
     ll=7.4510e-14      lw=0.0000e+00     lwl=0.0000e+00 \
    lln=1.0000e+00     lwn=1.0000e+00      wl=-1.968e-13 \
     ww=-1.514e-14     wwl=-1.321e-20     wln=1.0000e+00 \
     wr=1.0000e+00     wwn=1.0000e+00 \
     at=3.3000e+04     ute=-1.720e+00 \
    kt1=-4.180e-01     kt2=-4.560e-02    kt1l=0.0000e+00 \
    ua1=0.0000e+00     ub1=0.0000e+00     uc1=0.0000e+00 \
    prt=0.0000e+00 \
   cgso=1.0050e-10    cgdo=1.0050e-10    cgbo=1.6000e-08 \
   cgdl=1.0857e-10    cgsl=1.0857e-10  ckappa=2.9570e+00 \
     cf=0.0000e+00     elm=5.0000e+00 \
  xpart=1.0000e+00     clc=1.0000e-15     cle=6.0000e-01 \
\
   rdsw=2.5390e+03 \
   cdsc=0.0000e+00   cdscb=2.0000e-03   cdscd=0.0000e+00 \
   prwb=5.0000e-02    prwg=4.3480e-03     cit=0.0000e+00 \
tox=1.5000e-08 \
  ngate=1.0000e+00 \
    nlx=1.5690e-07 \
     xl=7.6070e-08      xw=0.0000e+00 \
     af=1.3580e+00      kf=3.4460e-26      ef=1.0000e+00 \
   noia=1.7020e+20    noib=5.4630e+05    noic=-1.400e-11 \
     rd=0.0000e+00      rs=0.0000e+00     rsh=8.9530e+01 \
   minr=1.000e-03 \
    rdc=0.0000e+00     rsc=0.0000e+00 lint=-2.609e-07 \
wint=-6.127e-07   ldif=0.000e+00    hdif=6.0000e-07 \
     xj=3.0000e-07      js=5.1000e-07 \
      n=1.0000e+00 \
  dskip=no          tlev=0           tlevc=0         \
    jsw=6.0000e-13 \
     cj=1.0380e-03    cjsw=3.1250e-10 \
     fc=0.0000e+00    fcsw=0.000e+00 \
     mj=3.4000e-01    mjsw=2.3000e-01 \
     pb=6.9000e-01    pbsw=6.9000e-01     xti=2.0300e+00
ends nmosmw_3n

// ----------------------------------------------------------------------

// ----------------------------------------------------------------------
// Owner: austriamicrosystems
// HIT-Kit: Digital
// ************************ SIMULATION PARAMETERS ************************
//  ----------------------------------------------------------------------
//  format    : Spectre (Spectre Direct)
//  model     : MOS BSIM3v3
//  process   : C35
//  revision  : 1.0;
//  extracted : C18069; 28.08.2011; bse (5866)
//  doc#      : Eng-?? REV_0
//  ----------------------------------------------------------------------
//                         WORST CASE ZERO CONDITION
//
//  ----------------------------------------------------------------------
//
inline subckt nmosmw_4n ( d g s b )
parameters w=1.0e-6 l=1.0e-6 nrd=0.0 nrs=0.0 ad=0.0 as=0.0 pd=0.0 ps=0.0 ng=1
+ ws= w
+ ls= l
+ shk=1
+ dvthmat=(mv_nmosmw_4n)*(1.03e-08/sqrt(ls*ws*ng)) dumat=(mu_nmosmw_4n)*(3.5e-9/sqrt(ls*ws*ng))
//
if (modnm==1)
nmosmw_4n ( d g s b ) mosinsub w=ws l=ls nrd=6.0000e-07/ws nrs=6.0000e-07/ws ad=ad as=as pd=pd ps=ps m=ng
else
nmosmw_4n ( d s ) resistor r=1e30
notvalid paramtest errorif=(modnm==0) \
message="
***************************************************
*
* nmosm is not valid in selected process option.
*
***************************************************"
model mosinsub bsim3v3 version=3.2400e+00  type=n  capmod=3.0000e+00 \
 mobmod=1.0000e+00  nqsmod=0.0000e+00  noimod=3.0000e+00 \
   vbox=1.000e+03      k1=8.4760e-01 \
     k2=0.0000e+00      k3=-2.500e+00     k3b=-5.640e-02 \
    nch=1.5560e+17 vth0=8.2170e-01+dvthmat \
   voff=-9.684e-02    dvt0=2.0510e+01    dvt1=1.0610e+00 \
   dvt2=2.5970e-02    keta=3.2000e-02 \
 pscbe1=1.0000e+30  pscbe2=1.0000e-06 \
 alpha0=5.5350e-08  alpha1=1.3930e-01   beta0=1.9570e+01 \
  dvt0w=1.0800e+01   dvt1w=3.0990e+06   dvt2w=1.4520e-01 \
     ua=4.5710e-10      ub=1.7380e-18      uc=5.7540e-11 \
u0=4.3850e+02+(4.3850e+02)*dumat \
   dsub=5.0000e-01    eta0=4.0860e-02    etab=-1.000e-03 \
nfactor=8.6050e-01 \
     em=4.1000e+07    pclm=9.0000e-01 \
  drout=5.0000e-01 \
     a0=1.0000e+00      a1=0.0000e+00      a2=1.0000e+00 \
   pvag=6.0000e-02    vsat=6.3000e+04     ags=1.4990e-01      b0=2.0000e-08      b1=1.0000e-08 \
  delta=1.0000e-02 pdiblcb=9.7980e-01 \
pdiblc1=3.2000e-02 pdiblc2=1.6680e-03 \
     w0=3.3160e-08 \
    dlc=1.3960e-09 \
dwc=-2.884e-01*l+1.4740e-07    dwb=8.6800e-09     dwg=-3.770e-09 \
     ll=6.7850e-14      lw=0.0000e+00     lwl=0.0000e+00 \
    lln=1.0000e+00     lwn=1.0000e+00      wl=-1.989e-13 \
     ww=-1.514e-14     wwl=-1.321e-20     wln=1.0000e+00 \
     wr=1.0000e+00     wwn=1.0000e+00 \
     at=3.3000e+04     ute=-1.720e+00 \
    kt1=-4.180e-01     kt2=-4.560e-02    kt1l=0.0000e+00 \
    ua1=0.0000e+00     ub1=0.0000e+00     uc1=0.0000e+00 \
    prt=0.0000e+00 \
   cgso=1.0050e-10    cgdo=1.0050e-10    cgbo=1.6000e-08 \
   cgdl=1.0800e-10    cgsl=1.0800e-10  ckappa=2.9570e+00 \
     cf=0.0000e+00     elm=5.0000e+00 \
  xpart=1.0000e+00     clc=1.0000e-15     cle=6.0000e-01 \
\
   rdsw=2.7670e+03 \
   cdsc=0.0000e+00   cdscb=2.0000e-03   cdscd=0.0000e+00 \
   prwb=2.0000e-02    prwg=1.0000e-02     cit=0.0000e+00 \
tox=1.5000e-08 \
  ngate=1.0000e+00 \
    nlx=1.5690e-07 \
     xl=6.5900e-08      xw=0.0000e+00 \
     af=1.3580e+00      kf=3.4460e-26      ef=1.0000e+00 \
   noia=1.7020e+20    noib=5.4630e+05    noic=-1.400e-11 \
     rd=0.0000e+00      rs=0.0000e+00     rsh=8.9530e+01 \
   minr=1.000e-03 \
    rdc=0.0000e+00     rsc=0.0000e+00 lint=-2.104e-07 \
wint=-7.006e-07   ldif=0.000e+00    hdif=6.0000e-07 \
     xj=3.0000e-07      js=5.1000e-07 \
      n=1.0000e+00 \
  dskip=no          tlev=0           tlevc=0         \
    jsw=6.0000e-13 \
     cj=1.0380e-03    cjsw=3.1250e-10 \
     fc=0.0000e+00    fcsw=0.000e+00 \
     mj=3.4000e-01    mjsw=2.3000e-01 \
     pb=6.9000e-01    pbsw=6.9000e-01     xti=2.0300e+00
ends nmosmw_4n

// ----------------------------------------------------------------------

// ----------------------------------------------------------------------
// Owner: austriamicrosystems
// HIT-Kit: Digital
// ************************ SIMULATION PARAMETERS ************************
//  ----------------------------------------------------------------------
//  format    : Spectre (Spectre Direct)
//  model     : MOS BSIM3v3
//  process   : C35
//  revision  : 1.0;
//  extracted : C18069; 28.08.2011; bse (5866)
//  doc#      : Eng-?? REV_0
//  ----------------------------------------------------------------------
//                         WORST CASE ZERO CONDITION
//
//  ----------------------------------------------------------------------
//
inline subckt pmosw_2n ( d g s b )
parameters w=1.0e-6 l=1.0e-6 nrd=0.0 nrs=0.0 ad=0.0 as=0.0 pd=0.0 ps=0.0 ng=1
+ ws= w
+ ls= l
+ shk=1
+ dvthmat=(mv_pmosw_2n)*(1.03e-08/sqrt(ls*ws*ng)) dumat=(mu_pmosw_2n)*(4.89e-9/sqrt(ls*ws*ng))
//
if (modp==1)
pmosw_2n ( d g s b ) mosinsub w=ws l=ls nrd=8.0000e-07/ws nrs=8.0000e-07/ws ad=ad as=as pd=pd ps=ps m=ng
else
pmosw_2n ( d s ) resistor r=1e30
notvalid paramtest errorif=(modp==0) \
message="
***************************************************
*
* pmos is not valid in selected process option.
*
***************************************************"
model mosinsub bsim3v3 version=3.2400e+00  type=p  capmod=3.0000e+00 \
 mobmod=1.0000e+00  nqsmod=0.0000e+00  noimod=3.0000e+00 \
   vbox=1.000e+03      k1=2.4220e-01 \
     k2=0.0000e+00      k3=5.2000e+00     k3b=-1.000e+00 \
    nch=8.0000e+16 vth0=-6.346e-01+dvthmat \
   voff=-1.640e-01    dvt0=2.2000e+00    dvt1=6.3470e-01 \
   dvt2=5.3690e-02    keta=-7.600e-03 \
 pscbe1=1.0000e+30  pscbe2=1.0000e-06 \
 alpha0=1.0000e-09  alpha1=1.1750e-02   beta0=2.2870e+01 \
  dvt0w=1.0090e-01   dvt1w=7.3400e+04   dvt2w=-6.310e-03 \
     ua=4.1690e-10      ub=1.9050e-18      uc=-3.631e-11 \
u0=1.9140e+02+(1.9140e+02)*dumat \
   dsub=5.0000e-01    eta0=2.4000e-01    etab=-3.917e-03 \
nfactor=1.0000e+00 \
     em=4.1000e+07    pclm=3.3380e+00 \
  drout=5.0000e-01 \
     a0=9.0000e-01      a1=1.4440e-15      a2=5.0780e-01 \
   pvag=1.0000e-03    vsat=6.0900e+04     ags=2.1480e-01      b0=2.1920e-07      b1=0.0000e+00 \
  delta=1.0000e-02 pdiblcb=1.0000e-02 \
pdiblc1=8.9340e+02 pdiblc2=1.8000e-03 \
     w0=-1.500e-07 \
    dlc=-2.929e-08 \
dwc=-3.000e-01*l+1.5000e-07    dwb=-5.244e-09     dwg=-1.100e-08 \
     ll=3.5530e-15      lw=0.0000e+00     lwl=0.0000e+00 \
    lln=1.0000e+00     lwn=1.0000e+00      wl=-1.712e-12 \
     ww=-4.300e-14     wwl=-2.884e-21     wln=1.0000e+00 \
     wr=1.0000e+00     wwn=1.0000e+00 \
     at=3.3000e+04     ute=-1.300e+00 \
    kt1=-4.740e-01     kt2=-5.440e-02    kt1l=-1.600e-08 \
    ua1=0.0000e+00     ub1=-3.802e-19     uc1=0.0000e+00 \
    prt=0.0000e+00 \
   cgso=9.0000e-11    cgdo=9.0000e-11    cgbo=1.7000e-08 \
   cgdl=1.2463e-10    cgsl=1.2463e-10  ckappa=1.0000e-01 \
     cf=0.0000e+00     elm=5.0000e+00 \
  xpart=1.0000e+00     clc=1.0000e-15     cle=6.0000e-01 \
\
   rdsw=1.0660e+04 \
   cdsc=1.2000e-02   cdscb=9.0000e-03   cdscd=1.0000e-03 \
   prwb=1.9620e-02    prwg=-3.558e-02     cit=0.0000e+00 \
tox=7.7540e-09 \
  ngate=0.0000e+00 \
    nlx=3.0770e-08 \
     xl=-1.160e-07      xw=0.0000e+00 \
     af=1.4050e+00      kf=1.8270e-26      ef=1.0000e+00 \
   noia=7.0910e+18    noib=6.0740e+04    noic=3.7790e-13 \
     rd=0.0000e+00      rs=0.0000e+00     rsh=1.0600e+02 \
   minr=1.000e-03 \
    rdc=0.0000e+00     rsc=0.0000e+00 lint=-7.965e-07 \
wint=-1.959e-06   ldif=0.000e+00    hdif=8.0000e-07 \
     xj=3.0000e-07      js=2.8000e-07 \
      n=1.0000e+00 \
  dskip=no          tlev=0           tlevc=0         \
    jsw=3.7000e-13 \
     cj=1.0200e-03    cjsw=2.6250e-10 \
     fc=0.0000e+00    fcsw=0.000e+00 \
     mj=5.4000e-01    mjsw=4.6000e-01 \
     pb=1.0200e+00    pbsw=1.0200e+00     xti=1.9730e+00
ends pmosw_2n

// ----------------------------------------------------------------------

// ----------------------------------------------------------------------
// Owner: austriamicrosystems
// HIT-Kit: Digital
// ************************ SIMULATION PARAMETERS ************************
//  ----------------------------------------------------------------------
//  format    : Spectre (Spectre Direct)
//  model     : MOS BSIM3v3
//  process   : C35
//  revision  : 1.0;
//  extracted : C18069; 28.08.2011; bse (5866)
//  doc#      : Eng-?? REV_0
//  ----------------------------------------------------------------------
//                         WORST CASE ZERO CONDITION
//
//  ----------------------------------------------------------------------
//
inline subckt pmosw_3n ( d g s b )
parameters w=1.0e-6 l=1.0e-6 nrd=0.0 nrs=0.0 ad=0.0 as=0.0 pd=0.0 ps=0.0 ng=1
+ ws= w
+ ls= l
+ shk=1
+ dvthmat=(mv_pmosw_3n)*(1.03e-08/sqrt(ls*ws*ng)) dumat=(mu_pmosw_3n)*(4.89e-9/sqrt(ls*ws*ng))
//
if (modp==1)
pmosw_3n ( d g s b ) mosinsub w=ws l=ls nrd=8.0000e-07/ws nrs=8.0000e-07/ws ad=ad as=as pd=pd ps=ps m=ng
else
pmosw_3n ( d s ) resistor r=1e30
notvalid paramtest errorif=(modp==0) \
message="
***************************************************
*
* pmos is not valid in selected process option.
*
***************************************************"
model mosinsub bsim3v3 version=3.2400e+00  type=p  capmod=3.0000e+00 \
 mobmod=1.0000e+00  nqsmod=0.0000e+00  noimod=3.0000e+00 \
   vbox=1.000e+03      k1=2.4220e-01 \
     k2=0.0000e+00      k3=5.2000e+00     k3b=-1.000e+00 \
    nch=8.0000e+16 vth0=-6.346e-01+dvthmat \
   voff=-1.640e-01    dvt0=2.2000e+00    dvt1=6.3470e-01 \
   dvt2=5.3690e-02    keta=-7.600e-03 \
 pscbe1=1.0000e+30  pscbe2=1.0000e-06 \
 alpha0=1.0000e-09  alpha1=1.1750e-02   beta0=2.2870e+01 \
  dvt0w=1.0090e-01   dvt1w=7.3400e+04   dvt2w=-6.310e-03 \
     ua=4.1690e-10      ub=1.9050e-18      uc=-3.631e-11 \
u0=1.9140e+02+(1.9140e+02)*dumat \
   dsub=5.0000e-01    eta0=2.4000e-01    etab=-3.917e-03 \
nfactor=1.0000e+00 \
     em=4.1000e+07    pclm=3.5650e+00 \
  drout=5.0000e-01 \
     a0=9.0000e-01      a1=1.4440e-15      a2=5.0780e-01 \
   pvag=4.6400e+00    vsat=1.0000e+05     ags=3.8020e-01      b0=2.1920e-07      b1=0.0000e+00 \
  delta=1.0000e-02 pdiblcb=1.0000e+00 \
pdiblc1=8.3320e+00 pdiblc2=2.0670e-03 \
     w0=-1.500e-07 \
    dlc=-2.929e-08 \
dwc=-3.000e-01*l+1.5000e-07    dwb=-5.244e-09     dwg=-1.100e-08 \
     ll=3.5530e-15      lw=0.0000e+00     lwl=0.0000e+00 \
    lln=1.0000e+00     lwn=1.0000e+00      wl=-5.064e-13 \
     ww=-4.300e-14     wwl=-2.884e-21     wln=1.0000e+00 \
     wr=1.0000e+00     wwn=1.0000e+00 \
     at=3.3000e+04     ute=-1.300e+00 \
    kt1=-4.740e-01     kt2=-5.440e-02    kt1l=-1.600e-08 \
    ua1=0.0000e+00     ub1=-3.802e-19     uc1=0.0000e+00 \
    prt=0.0000e+00 \
   cgso=9.0000e-11    cgdo=9.0000e-11    cgbo=1.7000e-08 \
   cgdl=1.2463e-10    cgsl=1.2463e-10  ckappa=1.0000e-01 \
     cf=0.0000e+00     elm=5.0000e+00 \
  xpart=1.0000e+00     clc=1.0000e-15     cle=6.0000e-01 \
\
   rdsw=5.7750e+03 \
   cdsc=1.2000e-02   cdscb=9.0000e-03   cdscd=1.0000e-03 \
   prwb=1.9620e-02    prwg=-1.019e-02     cit=0.0000e+00 \
tox=7.7540e-09 \
  ngate=0.0000e+00 \
    nlx=3.0770e-08 \
     xl=-8.408e-08      xw=0.0000e+00 \
     af=1.4050e+00      kf=1.8270e-26      ef=1.0000e+00 \
   noia=7.0910e+18    noib=6.0740e+04    noic=3.7790e-13 \
     rd=0.0000e+00      rs=0.0000e+00     rsh=1.0600e+02 \
   minr=1.000e-03 \
    rdc=0.0000e+00     rsc=0.0000e+00 lint=-3.275e-07 \
wint=-9.593e-07   ldif=0.000e+00    hdif=8.0000e-07 \
     xj=3.0000e-07      js=2.8000e-07 \
      n=1.0000e+00 \
  dskip=no          tlev=0           tlevc=0         \
    jsw=3.7000e-13 \
     cj=1.0200e-03    cjsw=2.6250e-10 \
     fc=0.0000e+00    fcsw=0.000e+00 \
     mj=5.4000e-01    mjsw=4.6000e-01 \
     pb=1.0200e+00    pbsw=1.0200e+00     xti=1.9730e+00
ends pmosw_3n

// ----------------------------------------------------------------------

// ----------------------------------------------------------------------
// Owner: austriamicrosystems
// HIT-Kit: Digital
// ************************ SIMULATION PARAMETERS ************************
//  ----------------------------------------------------------------------
//  format    : Spectre (Spectre Direct)
//  model     : MOS BSIM3v3
//  process   : C35
//  revision  : 1.0;
//  extracted : C18069; 28.08.2011; bse (5866)
//  doc#      : Eng-?? REV_0
//  ----------------------------------------------------------------------
//                         WORST CASE ZERO CONDITION
//
//  ----------------------------------------------------------------------
//
inline subckt pmosw_4n ( d g s b )
parameters w=1.0e-6 l=1.0e-6 nrd=0.0 nrs=0.0 ad=0.0 as=0.0 pd=0.0 ps=0.0 ng=1
+ ws= w
+ ls= l
+ shk=1
+ dvthmat=(mv_pmosw_4n)*(1.03e-08/sqrt(ls*ws*ng)) dumat=(mu_pmosw_4n)*(4.89e-9/sqrt(ls*ws*ng))
//
if (modp==1)
pmosw_4n ( d g s b ) mosinsub w=ws l=ls nrd=8.0000e-07/ws nrs=8.0000e-07/ws ad=ad as=as pd=pd ps=ps m=ng
else
pmosw_4n ( d s ) resistor r=1e30
notvalid paramtest errorif=(modp==0) \
message="
***************************************************
*
* pmos is not valid in selected process option.
*
***************************************************"
model mosinsub bsim3v3 version=3.2400e+00  type=p  capmod=3.0000e+00 \
 mobmod=1.0000e+00  nqsmod=0.0000e+00  noimod=3.0000e+00 \
   vbox=1.000e+03      k1=2.4220e-01 \
     k2=0.0000e+00      k3=5.2000e+00     k3b=-1.000e+00 \
    nch=8.0000e+16 vth0=-6.346e-01+dvthmat \
   voff=-1.640e-01    dvt0=2.2000e+00    dvt1=6.3470e-01 \
   dvt2=5.3690e-02    keta=-7.600e-03 \
 pscbe1=1.0000e+30  pscbe2=1.0000e-06 \
 alpha0=1.0000e-09  alpha1=1.1750e-02   beta0=2.2870e+01 \
  dvt0w=1.0090e-01   dvt1w=7.3400e+04   dvt2w=-6.310e-03 \
     ua=4.1690e-10      ub=1.9050e-18      uc=-3.631e-11 \
u0=1.9140e+02+(1.9140e+02)*dumat \
   dsub=5.0000e-01    eta0=2.4000e-01    etab=-3.917e-03 \
nfactor=1.0000e+00 \
     em=4.1000e+07    pclm=3.5650e+00 \
  drout=5.0000e-01 \
     a0=9.0000e-01      a1=1.4440e-15      a2=5.0780e-01 \
   pvag=4.6400e+00    vsat=1.5480e+05     ags=3.8020e-01      b0=2.1920e-07      b1=0.0000e+00 \
  delta=1.0000e-02 pdiblcb=1.0000e+00 \
pdiblc1=5.6700e+00 pdiblc2=3.0670e-03 \
     w0=-1.500e-07 \
    dlc=-2.929e-08 \
dwc=-3.000e-01*l+1.5000e-07    dwb=-5.244e-09     dwg=-1.100e-08 \
     ll=3.5530e-15      lw=0.0000e+00     lwl=0.0000e+00 \
    lln=1.0000e+00     lwn=1.0000e+00      wl=-5.064e-13 \
     ww=-4.300e-14     wwl=-2.884e-21     wln=1.0000e+00 \
     wr=1.0000e+00     wwn=1.0000e+00 \
     at=3.3000e+04     ute=-1.300e+00 \
    kt1=-4.740e-01     kt2=-5.440e-02    kt1l=-1.600e-08 \
    ua1=0.0000e+00     ub1=-3.802e-19     uc1=0.0000e+00 \
    prt=0.0000e+00 \
   cgso=9.0000e-11    cgdo=9.0000e-11    cgbo=1.7000e-08 \
   cgdl=1.2463e-10    cgsl=1.2463e-10  ckappa=1.0000e-01 \
     cf=0.0000e+00     elm=5.0000e+00 \
  xpart=1.0000e+00     clc=1.0000e-15     cle=6.0000e-01 \
\
   rdsw=5.7750e+03 \
   cdsc=1.2000e-02   cdscb=9.0000e-03   cdscd=1.0000e-03 \
   prwb=1.9620e-02    prwg=-7.244e-03     cit=0.0000e+00 \
tox=7.7540e-09 \
  ngate=0.0000e+00 \
    nlx=3.0770e-08 \
     xl=-7.800e-08      xw=0.0000e+00 \
     af=1.4050e+00      kf=1.8270e-26      ef=1.0000e+00 \
   noia=7.0910e+18    noib=6.0740e+04    noic=3.7790e-13 \
     rd=0.0000e+00      rs=0.0000e+00     rsh=1.0600e+02 \
   minr=1.000e-03 \
    rdc=0.0000e+00     rsc=0.0000e+00 lint=-2.996e-07 \
wint=-6.844e-07   ldif=0.000e+00    hdif=8.0000e-07 \
     xj=3.0000e-07      js=2.8000e-07 \
      n=1.0000e+00 \
  dskip=no          tlev=0           tlevc=0         \
    jsw=3.7000e-13 \
     cj=1.0200e-03    cjsw=2.6250e-10 \
     fc=0.0000e+00    fcsw=0.000e+00 \
     mj=5.4000e-01    mjsw=4.6000e-01 \
     pb=1.0200e+00    pbsw=1.0200e+00     xti=1.9730e+00
ends pmosw_4n

// ----------------------------------------------------------------------

// ----------------------------------------------------------------------
// Owner: austriamicrosystems
// HIT-Kit: Digital
// ************************ SIMULATION PARAMETERS ************************
//  ----------------------------------------------------------------------
//  format    : Spectre (Spectre Direct)
//  model     : MOS BSIM3v3
//  process   : C35
//  revision  : 1.0;
//  extracted : C18069; 28.08.2011; bse (5866)
//  doc#      : Eng-?? REV_0
//  ----------------------------------------------------------------------
//                         WORST CASE ZERO CONDITION
//
//  ----------------------------------------------------------------------
//
inline subckt pmosmw_2n ( d g s b )
parameters w=1.0e-6 l=1.0e-6 nrd=0.0 nrs=0.0 ad=0.0 as=0.0 pd=0.0 ps=0.0 ng=1
+ ws= w
+ ls= l
+ shk=1
+ dvthmat=(mv_pmosmw_2n)*(1.5e-08/sqrt(ls*ws*ng)) dumat=(mu_pmosmw_2n)*(4.3e-9/sqrt(ls*ws*ng))
//
if (modpm==1)
pmosmw_2n ( d g s b ) mosinsub w=ws l=ls nrd=6.0000e-07/ws nrs=6.0000e-07/ws ad=ad as=as pd=pd ps=ps m=ng
else
pmosmw_2n ( d s ) resistor r=1e30
notvalid paramtest errorif=(modpm==0) \
message="
***************************************************
*
* pmosm is not valid in selected process option.
*
***************************************************"
model mosinsub bsim3v3 version=3.2400e+00  type=p  capmod=3.0000e+00 \
 mobmod=1.0000e+00  nqsmod=0.0000e+00  noimod=3.0000e+00 \
   vbox=1.000e+03      k1=4.4140e-01 \
     k2=0.0000e+00      k3=1.8000e+00     k3b=-1.000e+00 \
    nch=7.6980e+16 vth0=-9.245e-01+dvthmat \
   voff=-1.148e-01    dvt0=1.7000e+00    dvt1=4.0100e-01 \
   dvt2=2.0050e-01    keta=2.0800e-02 \
 pscbe1=1.0000e+30  pscbe2=1.0000e-06 \
 alpha0=1.0000e-07  alpha1=3.1620e+00   beta0=4.2260e+01 \
  dvt0w=2.0000e-01   dvt1w=5.0000e+05   dvt2w=-3.200e+00 \
     ua=3.1000e-09      ub=2.2000e-19      uc=-8.318e-11 \
u0=2.5810e+02+(2.5810e+02)*dumat \
   dsub=5.0000e-01    eta0=1.7900e-03    etab=-2.948e-02 \
nfactor=7.0460e-01 \
     em=4.1000e+07    pclm=4.9580e+00 \
  drout=5.0000e-01 \
     a0=1.0000e+00      a1=6.0520e-05      a2=2.2110e-01 \
   pvag=1.0000e+00    vsat=5.0470e+04     ags=1.4450e-01      b0=1.3800e-07      b1=0.0000e+00 \
  delta=1.0000e-02 pdiblcb=6.0000e-02 \
pdiblc1=2.5900e+04 pdiblc2=2.4430e-03 \
     w0=-1.800e-07 \
    dlc=-1.766e-08 \
dwc=-2.953e-01*l+1.4210e-07    dwb=-4.580e-09     dwg=-6.295e-09 \
     ll=0.0000e+00      lw=0.0000e+00     lwl=0.0000e+00 \
    lln=1.0000e+00     lwn=1.0000e+00      wl=-3.685e-12 \
     ww=-3.900e-14     wwl=-4.467e-21     wln=1.0000e+00 \
     wr=1.0000e+00     wwn=1.0000e+00 \
     at=7.9640e+04     ute=-1.492e+00 \
    kt1=-5.480e-01     kt2=-6.000e-02    kt1l=-2.600e-08 \
    ua1=-2.630e-10     ub1=-3.311e-18     uc1=0.0000e+00 \
    prt=0.0000e+00 \
   cgso=1.0010e-10    cgdo=1.0010e-10    cgbo=8.0000e-09 \
   cgdl=9.9087e-11    cgsl=9.9087e-11  ckappa=1.3700e+00 \
     cf=0.0000e+00     elm=5.0000e+00 \
  xpart=1.0000e+00     clc=1.0000e-15     cle=6.0000e-01 \
\
   rdsw=1.0820e+04 \
   cdsc=1.2140e-03   cdscb=2.9450e-04   cdscd=0.0000e+00 \
   prwb=5.0700e-02    prwg=7.0360e-02     cit=5.2590e-05 \
tox=1.5000e-08 \
  ngate=0.0000e+00 \
    nlx=1.2500e-07 \
     xl=-1.800e-07      xw=0.0000e+00 \
     af=1.5640e+00      kf=4.8520e-26      ef=1.0000e+00 \
   noia=1.8720e+18    noib=3.4540e+04    noic=1.2460e-12 \
     rd=0.0000e+00      rs=0.0000e+00     rsh=1.0680e+02 \
   minr=1.000e-03 \
    rdc=0.0000e+00     rsc=0.0000e+00 lint=-1.646e-06 \
wint=-2.751e-06   ldif=0.000e+00    hdif=6.0000e-07 \
     xj=3.0000e-07      js=2.8000e-07 \
      n=1.0000e+00 \
  dskip=no          tlev=0           tlevc=0         \
    jsw=3.7000e-13 \
     cj=1.0200e-03    cjsw=2.6250e-10 \
     fc=0.0000e+00    fcsw=0.000e+00 \
     mj=5.4000e-01    mjsw=4.6000e-01 \
     pb=1.0200e+00    pbsw=1.0200e+00     xti=1.9700e+00
ends pmosmw_2n

// ----------------------------------------------------------------------

// ----------------------------------------------------------------------
// Owner: austriamicrosystems
// HIT-Kit: Digital
// ************************ SIMULATION PARAMETERS ************************
//  ----------------------------------------------------------------------
//  format    : Spectre (Spectre Direct)
//  model     : MOS BSIM3v3
//  process   : C35
//  revision  : 1.0;
//  extracted : C18069; 28.08.2011; bse (5866)
//  doc#      : Eng-?? REV_0
//  ----------------------------------------------------------------------
//                         WORST CASE ZERO CONDITION
//
//  ----------------------------------------------------------------------
//
inline subckt pmosmw_3n ( d g s b )
parameters w=1.0e-6 l=1.0e-6 nrd=0.0 nrs=0.0 ad=0.0 as=0.0 pd=0.0 ps=0.0 ng=1
+ ws= w
+ ls= l
+ shk=1
+ dvthmat=(mv_pmosmw_3n)*(1.5e-08/sqrt(ls*ws*ng)) dumat=(mu_pmosmw_3n)*(4.3e-9/sqrt(ls*ws*ng))
//
if (modpm==1)
pmosmw_3n ( d g s b ) mosinsub w=ws l=ls nrd=6.0000e-07/ws nrs=6.0000e-07/ws ad=ad as=as pd=pd ps=ps m=ng
else
pmosmw_3n ( d s ) resistor r=1e30
notvalid paramtest errorif=(modpm==0) \
message="
***************************************************
*
* pmosm is not valid in selected process option.
*
***************************************************"
model mosinsub bsim3v3 version=3.2400e+00  type=p  capmod=3.0000e+00 \
 mobmod=1.0000e+00  nqsmod=0.0000e+00  noimod=3.0000e+00 \
   vbox=1.000e+03      k1=4.4140e-01 \
     k2=0.0000e+00      k3=1.8000e+00     k3b=-1.000e+00 \
    nch=7.6980e+16 vth0=-9.245e-01+dvthmat \
   voff=-1.148e-01    dvt0=1.7000e+00    dvt1=4.0100e-01 \
   dvt2=2.0050e-01    keta=2.0800e-02 \
 pscbe1=1.0000e+30  pscbe2=1.0000e-06 \
 alpha0=1.0000e-07  alpha1=3.1620e+00   beta0=4.2260e+01 \
  dvt0w=2.0000e-01   dvt1w=5.0000e+05   dvt2w=-3.200e+00 \
     ua=3.1000e-09      ub=2.2000e-19      uc=-1.553e-10 \
u0=2.5810e+02+(2.5810e+02)*dumat \
   dsub=5.0000e-01    eta0=1.7900e-03    etab=-2.948e-02 \
nfactor=7.0460e-01 \
     em=4.1000e+07    pclm=4.9580e+00 \
  drout=5.0000e-01 \
     a0=1.0000e+00      a1=6.0520e-05      a2=2.2110e-01 \
   pvag=-1.500e+00    vsat=4.9050e+04     ags=1.4450e-01      b0=1.3800e-07      b1=0.0000e+00 \
  delta=1.0000e-02 pdiblcb=6.0000e-02 \
pdiblc1=2.6560e+02 pdiblc2=2.6870e-03 \
     w0=-1.800e-07 \
    dlc=-1.766e-08 \
dwc=-2.953e-01*l+1.4210e-07    dwb=-4.580e-09     dwg=-6.295e-09 \
     ll=0.0000e+00      lw=0.0000e+00     lwl=0.0000e+00 \
    lln=1.0000e+00     lwn=1.0000e+00      wl=-2.315e-12 \
     ww=-3.900e-14     wwl=-4.467e-21     wln=1.0000e+00 \
     wr=1.0000e+00     wwn=1.0000e+00 \
     at=7.9640e+04     ute=-1.492e+00 \
    kt1=-5.480e-01     kt2=-6.000e-02    kt1l=-2.600e-08 \
    ua1=-2.630e-10     ub1=-3.311e-18     uc1=0.0000e+00 \
    prt=0.0000e+00 \
   cgso=1.0010e-10    cgdo=1.0010e-10    cgbo=8.0000e-09 \
   cgdl=9.9087e-11    cgsl=9.9087e-11  ckappa=1.3700e+00 \
     cf=0.0000e+00     elm=5.0000e+00 \
  xpart=1.0000e+00     clc=1.0000e-15     cle=6.0000e-01 \
\
   rdsw=1.1340e+04 \
   cdsc=1.2140e-03   cdscb=2.9450e-04   cdscd=0.0000e+00 \
   prwb=-5.503e-02    prwg=1.5470e-02     cit=5.2590e-05 \
tox=1.5000e-08 \
  ngate=0.0000e+00 \
    nlx=1.2500e-07 \
     xl=-1.700e-07      xw=0.0000e+00 \
     af=1.5640e+00      kf=4.8520e-26      ef=1.0000e+00 \
   noia=1.8720e+18    noib=3.4540e+04    noic=1.2460e-12 \
     rd=0.0000e+00      rs=0.0000e+00     rsh=1.0680e+02 \
   minr=1.000e-03 \
    rdc=0.0000e+00     rsc=0.0000e+00 lint=-1.020e-06 \
wint=-1.770e-06   ldif=0.000e+00    hdif=6.0000e-07 \
     xj=3.0000e-07      js=2.8000e-07 \
      n=1.0000e+00 \
  dskip=no          tlev=0           tlevc=0         \
    jsw=3.7000e-13 \
     cj=1.0200e-03    cjsw=2.6250e-10 \
     fc=0.0000e+00    fcsw=0.000e+00 \
     mj=5.4000e-01    mjsw=4.6000e-01 \
     pb=1.0200e+00    pbsw=1.0200e+00     xti=1.9700e+00
ends pmosmw_3n

// ----------------------------------------------------------------------

// ----------------------------------------------------------------------
// Owner: austriamicrosystems
// HIT-Kit: Digital
// ************************ SIMULATION PARAMETERS ************************
//  ----------------------------------------------------------------------
//  format    : Spectre (Spectre Direct)
//  model     : MOS BSIM3v3
//  process   : C35
//  revision  : 1.0;
//  extracted : C18069; 28.08.2011; bse (5866)
//  doc#      : Eng-?? REV_0
//  ----------------------------------------------------------------------
//                         WORST CASE ZERO CONDITION
//
//  ----------------------------------------------------------------------
//
inline subckt pmosmw_4n ( d g s b )
parameters w=1.0e-6 l=1.0e-6 nrd=0.0 nrs=0.0 ad=0.0 as=0.0 pd=0.0 ps=0.0 ng=1
+ ws= w
+ ls= l
+ shk=1
+ dvthmat=(mv_pmosmw_4n)*(1.5e-08/sqrt(ls*ws*ng)) dumat=(mu_pmosmw_4n)*(4.3e-9/sqrt(ls*ws*ng))
//
if (modpm==1)
pmosmw_4n ( d g s b ) mosinsub w=ws l=ls nrd=6.0000e-07/ws nrs=6.0000e-07/ws ad=ad as=as pd=pd ps=ps m=ng
else
pmosmw_4n ( d s ) resistor r=1e30
notvalid paramtest errorif=(modpm==0) \
message="
***************************************************
*
* pmosm is not valid in selected process option.
*
***************************************************"
model mosinsub bsim3v3 version=3.2400e+00  type=p  capmod=3.0000e+00 \
 mobmod=1.0000e+00  nqsmod=0.0000e+00  noimod=3.0000e+00 \
   vbox=1.000e+03      k1=4.4140e-01 \
     k2=0.0000e+00      k3=1.8000e+00     k3b=-1.000e+00 \
    nch=7.6980e+16 vth0=-9.245e-01+dvthmat \
   voff=-1.148e-01    dvt0=1.7000e+00    dvt1=4.0100e-01 \
   dvt2=2.0050e-01    keta=2.0800e-02 \
 pscbe1=1.0000e+30  pscbe2=1.0000e-06 \
 alpha0=1.0000e-07  alpha1=3.1620e+00   beta0=4.2260e+01 \
  dvt0w=2.0000e-01   dvt1w=5.0000e+05   dvt2w=-3.200e+00 \
     ua=3.1000e-09      ub=2.2000e-19      uc=-8.318e-11 \
u0=2.5810e+02+(2.5810e+02)*dumat \
   dsub=5.0000e-01    eta0=1.7900e-03    etab=-2.948e-02 \
nfactor=7.0460e-01 \
     em=4.1000e+07    pclm=4.9580e+00 \
  drout=5.0000e-01 \
     a0=1.0000e+00      a1=6.0520e-05      a2=2.2110e-01 \
   pvag=-1.500e+00    vsat=6.7470e+04     ags=1.4450e-01      b0=1.3800e-07      b1=0.0000e+00 \
  delta=1.0000e-02 pdiblcb=6.0000e-02 \
pdiblc1=2.8350e+01 pdiblc2=3.8950e-03 \
     w0=-1.800e-07 \
    dlc=-1.766e-08 \
dwc=-2.953e-01*l+1.4210e-07    dwb=-4.580e-09     dwg=-6.295e-09 \
     ll=0.0000e+00      lw=0.0000e+00     lwl=0.0000e+00 \
    lln=1.0000e+00     lwn=1.0000e+00      wl=-1.534e-12 \
     ww=-3.900e-14     wwl=-4.467e-21     wln=1.0000e+00 \
     wr=1.0000e+00     wwn=1.0000e+00 \
     at=7.9640e+04     ute=-1.492e+00 \
    kt1=-5.480e-01     kt2=-6.000e-02    kt1l=-2.600e-08 \
    ua1=-2.630e-10     ub1=-3.311e-18     uc1=0.0000e+00 \
    prt=0.0000e+00 \
   cgso=1.0010e-10    cgdo=1.0010e-10    cgbo=8.0000e-09 \
   cgdl=9.9087e-11    cgsl=9.9087e-11  ckappa=1.3700e+00 \
     cf=0.0000e+00     elm=5.0000e+00 \
  xpart=1.0000e+00     clc=1.0000e-15     cle=6.0000e-01 \
\
   rdsw=6.6990e+03 \
   cdsc=1.2140e-03   cdscb=2.9450e-04   cdscd=0.0000e+00 \
   prwb=5.0700e-02    prwg=7.7360e-02     cit=5.2590e-05 \
tox=1.5000e-08 \
  ngate=0.0000e+00 \
    nlx=1.2500e-07 \
     xl=-1.341e-07      xw=0.0000e+00 \
     af=1.5640e+00      kf=4.8520e-26      ef=1.0000e+00 \
   noia=1.8720e+18    noib=3.4540e+04    noic=1.2460e-12 \
     rd=0.0000e+00      rs=0.0000e+00     rsh=1.0680e+02 \
   minr=1.000e-03 \
    rdc=0.0000e+00     rsc=0.0000e+00 lint=-7.278e-07 \
wint=-1.000e-06   ldif=0.000e+00    hdif=6.0000e-07 \
     xj=3.0000e-07      js=2.8000e-07 \
      n=1.0000e+00 \
  dskip=no          tlev=0           tlevc=0         \
    jsw=3.7000e-13 \
     cj=1.0200e-03    cjsw=2.6250e-10 \
     fc=0.0000e+00    fcsw=0.000e+00 \
     mj=5.4000e-01    mjsw=4.6000e-01 \
     pb=1.0200e+00    pbsw=1.0200e+00     xti=1.9700e+00
ends pmosmw_4n

// ----------------------------------------------------------------------

// ----------------------------------------------------------------------
// Owner: austriamicrosystems
// HIT-Kit: Digital
//************************ SIMULATION PARAMETERS ************************
// ----------------------------------------------------------------------
// format    : Spectre
// model     : MODNRF
// process   : CS ADFI
// revision  : 3.1;
// extracted : CSD C64330.04e3; 2002-09; kmo(5966)
// doc#      : ENG-188 REV_5
// ----------------------------------------------------------------------
//                        WORST CASE ZERO CONDITION
// ----------------------------------------------------------------------
//
//  RF CMOS TRANSISTOR MODEL
//
//-----------------------------------------------------------------------
inline subckt modnrf ( d g s b )
parameters w=1.0e-6 l=1.0e-6 nrd=0.0 nrs=0.0 ad=0.0 as=0.0 pd=0.0 ps=0.0 ng=1
+ mmvth_modnrf=0.0 mmu0_modnrf=0.0
+ dvthmat=(mv_modnrf53+mmvth_modnrf)*(0.67e-08/sqrt(l*w*ng)) dumat=(mu_modnrf53+mmu0_modnrf)*(4.9e-9/sqrt(l*w*ng))
// //
if (modnrf==1){
// --------- Gate network ------------------------------
lg  (g 20 ) inductor l=1.000e-15
rg  (20 21 ) resistor r=((6.895e-04/w+4.758e+01 )/ng+(3.726e+05*w+2.740e+00)) isnoisy=yes
//
// --------- Drain network -----------------------------
ldrain ( d 13 ) inductor l=1.000e-15
rdrain ( 13 11 ) resistor r=(3.320e-04/(w*ng)+1.669e-01) isnoisy=yes
//
// --------- Source network -----------------------------
lsource ( s 33 ) inductor l=1.000e-15
rsource ( 33 31 ) resistor r=(3.320e-04/(w*ng)+1.669e-01) isnoisy=yes
//
// --------- Substrate network -------------------------
// Diodes are for n-type or p-type MOS transistors
//
djdb  ( 12 11 ) bulk_diode area=ad*ng perim=pd*ng
djsb  ( 32 31 ) bulk_diode area=as*ng perim=ps*ng
//
rsub1 ( 12 b ) resistor r=((0.000e+00/w+0.000e+00)/ng+(9.524e+06*w+(4.156e+01))) isnoisy=yes
rsub2 ( 32 b ) resistor r=((0.000e+00/w+0.000e+00)/ng+(9.524e+06*w+(4.156e+01))) isnoisy=yes
//
// --------- Ideal mos transistor ----------------------
modnrf ( 11 21 31 b ) mosinsub l=l w=w*ng ad=0.0 as=0.0 pd=0.0 ps=0.0 nrd=0 nrs=0
}else
modnrf ( d s ) resistor r=1e30
notvalid paramtest errorif=(modnrf==0) \
message="
***************************************************
*
* nmosrf is not valid in selected process option.
*
***************************************************"
// Intrinsic MOS transistor
model mosinsub bsim3v3 version=3.1 type=n  capmod=2.0000e+00 \
 mobmod=1.0000e+00  nqsmod=0.0000e+00  noimod=3 \
   vbox=1.000e+03      k1=7.0007e-01 \
     k2=-1.076e-02      k3=-1.715e+00     k3b=6.3250e-01 \
    nch=2.7470e+17 vth0=5.3550e-01+dvthmat \
   voff=-5.719e-02    dvt0=2.2270e+01    dvt1=1.0510e+00 \
   dvt2=3.3930e-03    keta=-6.207e-04 \
 pscbe1=2.7560e+08  pscbe2=9.6450e-06 \
 alpha0=0.0000e+00   beta0=3.0000e+01 \
  dvt0w=0.0000e+00   dvt1w=0.0000e+00   dvt2w=0.0000e+00 \
     ua=1.0000e-12      ub=4.8510e-18      uc=5.7560e-11 \
u0=6.1140e+02+(6.1140e+02)*dumat \
   dsub=5.0000e-01    eta0=3.0850e-02    etab=-3.947e-02 \
nfactor=1.1190e-01 \
     em=4.1000e+07    pclm=1.5270e+00 \
  drout=5.0000e-01 \
     a0=2.2080e+00      a1=0.0000e+00      a2=1.0000e+00 \
   pvag=0.0000e+00    vsat=7.5800e+04     ags=2.4900e-01      b0=-1.765e-08      b1=0.0000e+00 \
  delta=1.0000e-02 pdiblcb=2.5830e-01 \
pdiblc1=1.0760e-01 pdiblc2=1.4530e-03 \
     w0=1.1840e-07 \
    dlc=6.6050e-08 \
    dwc=2.6760e-08     dwb=0.0000e+00     dwg=0.0000e+00 \
     ll=0.000e+00      lw=0.000e+00     lwl=0.000e+00 \
    lln=1.000e+00     lwn=1.000e+00      wl=0.0000e+00 \
     ww=0.0000e+00     wwl=0.0000e+00     wln=1.0000e+00 \
     wr=1.0000e+00     wwn=1.0000e+00 \
     at=3.3000e+04     ute=-1.800e+00 \
    kt1=-3.302e-01     kt2=2.2000e-02    kt1l=0.0000e+00 \
    ua1=0.0000e+00     ub1=0.0000e+00     uc1=0.0000e+00 \
    prt=0.0000e+00 \
   cgso=1.8730e-10    cgdo=1.8730e-10    cgbo=1.1000e-10 \
   cgdl=1.2547e-10    cgsl=1.2547e-10  ckappa=6.0000e-01 \
     cf=0.0000e+00     elm=5.0000e+00 \
  xpart=1.0000e+00     clc=1.0000e-15     cle=6.0000e-01 \
\
   rdsw=0.0000e+00 \
   cdsc=0.0000e+00   cdscb=0.0000e+00   cdscd=8.4480e-05 \
   prwb=0.0000e+00    prwg=0.0000e+00     cit=1.0000e-03 \
tox=7.5000e-09 \
  ngate=0.0000e+00 \
    nlx=1.9180e-07 \
     xl=5.0000e-08      xw=2.5000e-08 \
     af=1.5070e+00      kf=2.1700e-26      ef=1.0000e+00 \
   noia=1.1210e+19    noib=5.3360e+04    noic=-5.892e-13 \
     rd=0.0000e+00      rs=0.0000e+00     rsh=8.2000e+01 \
   minr=1.000e-03 \
    rdc=0.0000e+00     rsc=0.0000e+00 lint=8.2850e-09 \
wint=2.6760e-08   ldif=0.000e+00    hdif=6.0000e-07 \
     xj=3.0000e-07      js=5.1000e-07 \
      n=1.0000e+00 \
  dskip=no          tlev=0           tlevc=0         \
    jsw=0.0000e+00 \
     cj=0.0000e+00    cjsw=0.0000e+00 \
     fc=0.0000e+00    fcsw=0.000e+00 \
     mj=3.1000e-01    mjsw=1.9000e-01 \
     pb=6.9000e-01    pbsw=6.9000e-01
// Bulk Diode Model
model bulk_diode diode level=1 dskip=no \
     is=5.100e-07      isw=0.600e-12       n=1.0000000       ns=1.0000000   \
    cjo=1.580e-03       m=3.100e-01 \
    cjsw=0.000e+00       mjsw=2.011E-01 \
     fc=0.000e+00      tt=0.000e+00      vj=6.900e-01      vjsw=6.672E-01  \
     kf=0.000e+00      eg=1.11e+00     xti=2.026e+00      af=1.000e+00
ends modnrf
// ----------------------------------------------------------------------
// ----------------------------------------------------------------------
// Owner: austriamicrosystems
// HIT-Kit: Digital
//************************ SIMULATION PARAMETERS ************************
// ----------------------------------------------------------------------
// format    : Spectre
// model     : MODPRF
// process   : C/B/S 35
// revision  : 3.1;
// extracted : C35B3 B11634.L1 04PA3; 2002-09; kmo(5966)
// doc#      : ENG-188 REV_5
// ----------------------------------------------------------------------
//                        WORST CASE ZERO CONDITION
// ----------------------------------------------------------------------
//
//  RF CMOS TRANSISTOR MODEL
//
//-----------------------------------------------------------------------
inline subckt modprf ( d g s b )
parameters w=1.0e-6 l=1.0e-6 nrd=0.0 nrs=0.0 ad=0.0 as=0.0 pd=0.0 ps=0.0 ng=1
+ mmvth_modprf=0.0 mmu0_modprf=0.0
+ dvthmat=(mv_modprf53+mmvth_modprf)*(1.03e-08/sqrt(l*w*ng)) dumat=(mu_modprf53+mmu0_modprf)*(7.1e-9/sqrt(l*w*ng))
// //
if (modprf==1){
// --------- Gate network ------------------------------
lg  (g 20 ) inductor l=1.000e-15
rg  (20 21 ) resistor r=((-5.800e-04/w+2.884e+02 )/ng+(-5.394e+05*w+1.596e+00)) isnoisy=yes
//
// --------- Drain network -----------------------------
ldrain ( d 13 ) inductor l=1.000e-15
rdrain ( 13 11 ) resistor r=(8.051e-04/(w*ng)+1.731e+00) isnoisy=yes
//
// --------- Source network -----------------------------
lsource ( s 33 ) inductor l=1.000e-15
rsource ( 33 31 ) resistor r=(8.051e-04/(w*ng)+1.731e+00) isnoisy=yes
//
// --------- Substrate network -------------------------
// Diodes are for n-type or p-type MOS transistors
//
djdb  ( 11 12 ) bulk_diode area=ad*ng perim=pd*ng
djsb  ( 31 32 ) bulk_diode area=as*ng perim=ps*ng
//
rsub1 ( 12 b ) resistor r=((1.064e-04/w+1.682e+02)/ng+(1.724e+06*w+(-2.292e+00))) isnoisy=yes
rsub2 ( 32 b ) resistor r=((1.064e-04/w+1.682e+02)/ng+(1.724e+06*w+(-2.292e+00))) isnoisy=yes
//
// --------- Ideal mos transistor ----------------------
modprf ( 11 21 31 b ) mosinsub l=l w=w*ng ad=0.0 as=0.0 pd=0.0 ps=0.0 nrd=0 nrs=0
}else
modprf ( d s ) resistor r=1e30
notvalid paramtest errorif=(modprf==0) \
message="
***************************************************
*
* pmosrf is not valid in selected process option.
*
***************************************************"
// Intrinsic MOS transistor
model mosinsub bsim3v3 version=3.1 type=p  capmod=2.0000e+00 \
 mobmod=1.0000e+00  nqsmod=0.0000e+00  noimod=3 \
   vbox=1.000e+03      k1=3.0459e-01 \
     k2=3.1999e-02      k3=1.1030e+01     k3b=-7.580e-01 \
    nch=1.1000e+17 vth0=-6.299e-01+dvthmat \
   voff=-1.170e-01    dvt0=1.6500e+00    dvt1=3.8680e-01 \
   dvt2=1.6590e-02    keta=-1.440e-02 \
 pscbe1=5.0000e+09  pscbe2=1.0000e-04 \
 alpha0=0.0000e+00   beta0=3.0000e+01 \
  dvt0w=1.8790e-01   dvt1w=7.3350e+04   dvt2w=-6.312e-03 \
     ua=5.3940e-10      ub=3.9760e-19      uc=1.0000e-20 \
u0=1.4420e+02+(1.4420e+02)*dumat \
   dsub=5.0000e-01    eta0=2.4800e-01    etab=-3.917e-03 \
nfactor=1.2140e+00 \
     em=4.1000e+07    pclm=1.8290e+00 \
  drout=5.0000e-01 \
     a0=5.8500e-01      a1=0.0000e+00      a2=1.0000e+00 \
   pvag=0.0000e+00    vsat=4.8240e+04     ags=2.4680e-01      b0=8.8320e-08      b1=0.0000e+00 \
  delta=1.0000e-02 pdiblcb=1.0000e+00 \
pdiblc1=1.0000e-04 pdiblc2=1.0000e-20 \
     w0=1.0000e-10 \
    dlc=5.6730e-08 \
    dwc=3.4490e-08     dwb=0.0000e+00     dwg=0.0000e+00 \
     ll=0.000e+00      lw=0.000e+00     lwl=0.000e+00 \
    lln=1.000e+00     lwn=1.000e+00      wl=0.0000e+00 \
     ww=1.8940e-16     wwl=-1.981e-21     wln=1.0000e+00 \
     wr=1.0000e+00     wwn=1.0400e+00 \
     at=3.3000e+04     ute=-1.300e+00 \
    kt1=-5.403e-01     kt2=2.2000e-02    kt1l=0.0000e+00 \
    ua1=0.0000e+00     ub1=0.0000e+00     uc1=0.0000e+00 \
    prt=0.0000e+00 \
   cgso=1.0000e-12    cgdo=1.0000e-12    cgbo=1.1000e-10 \
   cgdl=2.3813e-10    cgsl=2.3813e-10  ckappa=6.0000e-01 \
     cf=0.0000e+00     elm=5.0000e+00 \
  xpart=1.0000e+00     clc=1.0000e-15     cle=6.0000e-01 \
\
   rdsw=0.0000e+00 \
   cdsc=2.5890e-03   cdscb=2.9430e-04   cdscd=4.3700e-04 \
   prwb=-9.731e-02    prwg=1.4770e-01     cit=0.0000e+00 \
tox=7.6000e-09 \
  ngate=0.0000e+00 \
    nlx=1.7700e-07 \
     xl=-6.000e-08      xw=5.0000e-09 \
     af=1.4050e+00      kf=1.8270e-26      ef=1.0000e+00 \
   noia=7.0910e+18    noib=6.0740e+04    noic=3.7790e-13 \
     rd=0.0000e+00      rs=0.0000e+00     rsh=1.2900e+02 \
   minr=1.000e-03 \
    rdc=0.0000e+00     rsc=0.0000e+00 lint=-1.164e-08 \
wint=3.4490e-08   ldif=0.000e+00    hdif=8.0000e-07 \
     xj=3.0000e-07      js=2.8000e-07 \
      n=1.0000e+00 \
  dskip=no          tlev=0           tlevc=0         \
    jsw=3.7000e-13 \
     cj=0.0000e+00    cjsw=0.0000e+00 \
     fc=0.0000e+00    fcsw=0.000e+00 \
     mj=5.6000e-01    mjsw=4.3000e-01 \
     pb=1.0200e+00    pbsw=1.0200e+00     xti=1.9700e+00
// Bulk Diode Model
model bulk_diode diode level=1 dskip=no \
     is=2.800e-07      isw=3.700e-13       n=1.0000000       ns=1.0000000   \
    cjo=1.526e-03       m=1.176e-01 \
    cjsw=0.000e+00       mjsw=4.300e-01 \
     fc=0.000e+00      tt=0.000e+00      vj=1.020e+00      vjsw=1.020e+00  \
     kf=0.000e+00      eg=1.11e+00     xti=1.973e+00      af=1.000e+00
ends modprf
// ----------------------------------------------------------------------
//-------------- END OF Section ------------------
endsection
section cmostmwn
//
// ----------------------------------------------------------------------
// Owner: austriamicrosystems
// HIT-Kit: Digital
// ************************ SIMULATION PARAMETERS ************************
//  ----------------------------------------------------------------------
//  format    : Spectre (Spectre Direct)
//  model     : MOS BSIM3v3
//  process   : C35
//  revision  : 4.0;
//  extracted : B10866 ; 2002-12; ese(5487)
//  doc#      : ENG-182 REV_6
//  ----------------------------------------------------------------------
//                    TYPICAL MEAN WORST NOISE CONDITION
//
//  ----------------------------------------------------------------------
//
inline subckt modn ( d g s b )
parameters w=1.0e-6 l=1.0e-6 nrd=0.0 nrs=0.0 ad=0.0 as=0.0 pd=0.0 ps=0.0 ng=1
+ ws= w
+ ls= l
+ shk=1
+ dvthmat=(mv_modn)*(0.67e-08/sqrt(ls*ws*ng)) dumat=(mu_modn)*(4.9e-9/sqrt(ls*ws*ng))
//
if (modn==1)
modn ( d g s b ) mosinsub w=ws l=ls nrd=nrd nrs=nrs ad=ad as=as pd=pd ps=ps m=ng
else
modn ( d s ) resistor r=1e30
notvalid paramtest errorif=(modn==0) \
message="
***************************************************
*
* nmos is not valid in selected process option.
*
***************************************************"
model mosinsub bsim3v3 version=3.2400e+00  type=n  capmod=2.0000e+00 \
 mobmod=1.0000e+00  nqsmod=0.0000e+00  noimod=3 \
   vbox=1.000e+03      k1=5.0296e-01 \
     k2=3.3985e-02      k3=-1.136e+00     k3b=-4.399e-01 \
    nch=2.6110e+17 vth0=4.9790e-01+dvthmat \
   voff=-8.925e-02    dvt0=5.0000e+01    dvt1=1.0390e+00 \
   dvt2=-8.375e-03    keta=2.0320e-02 \
 pscbe1=1.0000e+30  pscbe2=1.0000e-06 \
 alpha0=2.6000e-06  alpha1=5.0000e+00   beta0=2.1000e+01 \
  dvt0w=1.0890e-01   dvt1w=6.6710e+04   dvt2w=-1.352e-02 \
     ua=4.7050e-12      ub=2.1370e-18      uc=1.0000e-20 \
u0=4.7580e+02+(4.7580e+02)*dumat \
   dsub=5.0000e-01    eta0=1.4150e-02    etab=-1.221e-01 \
nfactor=4.1360e-01 \
     em=4.1000e+07    pclm=6.9480e-01 \
  drout=5.0000e-01 \
     a0=2.5410e+00      a1=0.0000e+00      a2=1.0000e+00 \
   pvag=0.0000e+00    vsat=1.3380e+05     ags=2.4080e-01      b0=4.3010e-09      b1=0.0000e+00 \
  delta=1.4420e-02 pdiblcb=3.2220e-01 \
pdiblc1=3.5710e-01 pdiblc2=2.0650e-03 \
     w0=2.6730e-07 \
    dlc=3.0000e-08 \
    dwc=9.4030e-08     dwb=0.0000e+00     dwg=0.0000e+00 \
     ll=0.000e+00      lw=0.000e+00     lwl=0.000e+00 \
    lln=1.000e+00     lwn=1.000e+00      wl=0.0000e+00 \
     ww=-1.297e-14     wwl=-9.411e-21     wln=1.0000e+00 \
    wwn=1.0000e+00 \
     at=3.3000e+04     ute=-1.800e+00 \
    kt1=-3.302e-01     kt2=2.2000e-02    kt1l=0.0000e+00 \
    ua1=0.0000e+00     ub1=0.0000e+00     uc1=0.0000e+00 \
    prt=0.0000e+00 \
   cgso=1.2000e-10    cgdo=1.2000e-10    cgbo=1.1000e-10 \
   cgdl=1.3100e-10    cgsl=1.3100e-10  ckappa=6.0000e-01 \
     cf=0.0000e+00     elm=5.0000e+00 \
  xpart=1.0000e+00     clc=1.0000e-15     cle=6.0000e-01 \
   noff=1.0000e+00  voffcv=0.0000e+00 \
   rdsw=3.4490e+02 \
   cdsc=0.0000e+00   cdscb=1.5000e-03   cdscd=1.0000e-03 \
   prwb=-2.416e-01    prwg=0.0000e+00     cit=4.4410e-04 \
tox=7.5750e-09 \
  ngate=0.0000e+00 \
    nlx=1.8880e-07 \
     xl=0.0000e+00      xw=0.0000e+00 \
     af=1.3760e+00      kf=3.3960e-26      ef=1.0000e+00 \
   noia=1.3990e+20    noib=2.7070e+05    noic=-4.680e-12 \
     rd=0.0000e+00      rs=0.0000e+00     rsh=7.0000e+01 \
   minr=1.000e-03 \
    rdc=0.0000e+00     rsc=0.0000e+00 lint=-5.005e-08 \
wint=9.4030e-08   ldif=0.000e+00    hdif=8.0000e-07 \
     xj=3.0000e-07      js=5.1000e-07 \
      n=1.0000e+00 \
  dskip=no          tlev=0           tlevc=0         \
    jsw=6.0000e-13 \
     cj=8.4000e-04    cjsw=2.5000e-10 \
     fc=0.0000e+00    fcsw=0.000e+00 \
     mj=3.4000e-01    mjsw=2.3000e-01 \
     pb=6.9000e-01    pbsw=6.9000e-01     xti=2.0260e+00
ends modn

// ----------------------------------------------------------------------
// ----------------------------------------------------------------------
// Owner: austriamicrosystems
// HIT-Kit: Digital
// ************************ SIMULATION PARAMETERS ************************
//  ----------------------------------------------------------------------
//  format    : Spectre (Spectre Direct)
//  model     : MOS BSIM3v3
//  process   : C35
//  revision  : 4.1;
//  extracted : B11004 ; 2002-12; ese(5487)
//  doc#      : ENG-182 REV_6
//  ----------------------------------------------------------------------
//                    TYPICAL MEAN WORST NOISE CONDITION
//
//  ----------------------------------------------------------------------
//
inline subckt modnm ( d g s b )
parameters w=1.0e-6 l=1.0e-6 nrd=0.0 nrs=0.0 ad=0.0 as=0.0 pd=0.0 ps=0.0 ng=1
+ ws= w
+ ls= l
+ shk=1
+ dvthmat=(mv_modnm)*(1.03e-08/sqrt(ls*ws*ng)) dumat=(mu_modnm)*(3.5e-9/sqrt(ls*ws*ng))
//
if (modnm==1)
modnm ( d g s b ) mosinsub w=ws l=ls nrd=nrd nrs=nrs ad=ad as=as pd=pd ps=ps m=ng
else
modnm ( d s ) resistor r=1e30
notvalid paramtest errorif=(modnm==0) \
message="
***************************************************
*
* nmosm is not valid in selected process option.
*
***************************************************"
model mosinsub bsim3v3 version=3.2400e+00  type=n  capmod=2.0000e+00 \
 mobmod=1.0000e+00  nqsmod=0.0000e+00  noimod=3 \
   vbox=1.000e+03      k1=7.4922e-01 \
     k2=1.1026e-01      k3=-3.776e+00     k3b=-7.691e-02 \
    nch=2.2650e+17 vth0=7.5250e-01+dvthmat \
   voff=-8.295e-02    dvt0=3.0000e+01    dvt1=1.5280e+00 \
   dvt2=2.5290e-02    keta=3.5850e-02 \
 pscbe1=1.0000e+30  pscbe2=1.0000e-06 \
 alpha0=7.7410e-09  alpha1=3.9830e-01   beta0=2.0700e+01 \
  dvt0w=-5.000e+00   dvt1w=2.5780e+06   dvt2w=5.1050e-02 \
     ua=4.7080e-10      ub=1.4700e-18      uc=-4.342e-11 \
u0=5.6430e+02+(5.6430e+02)*dumat \
   dsub=5.0000e-01    eta0=3.7950e-02    etab=-7.653e-04 \
nfactor=8.5730e-01 \
     em=4.1000e+07    pclm=2.1250e-01 \
  drout=5.0000e-01 \
     a0=2.0640e+00      a1=0.0000e+00      a2=1.0000e+00 \
   pvag=0.0000e+00    vsat=1.0780e+05     ags=1.0790e-01      b0=-1.493e-07      b1=0.0000e+00 \
  delta=1.0000e-02 pdiblcb=5.1860e-01 \
pdiblc1=1.0000e-04 pdiblc2=5.4580e-04 \
     w0=1.6170e-07 \
    dlc=1.0000e-07 \
    dwc=1.6230e-07     dwb=0.0000e+00     dwg=0.0000e+00 \
     ll=0.000e+00      lw=0.000e+00     lwl=0.000e+00 \
    lln=1.000e+00     lwn=1.000e+00      wl=0.0000e+00 \
     ww=-5.117e-14     wwl=-5.704e-21     wln=1.0000e+00 \
    wwn=1.0000e+00 \
     at=3.3000e+04     ute=-1.760e+00 \
    kt1=-4.502e-01     kt2=2.2000e-02    kt1l=0.0000e+00 \
    ua1=0.0000e+00     ub1=0.0000e+00     uc1=0.0000e+00 \
    prt=0.0000e+00 \
   cgso=1.0800e-10    cgdo=1.0800e-10    cgbo=1.1000e-10 \
   cgdl=2.2700e-10    cgsl=2.2700e-10  ckappa=6.0000e-01 \
     cf=0.0000e+00     elm=5.0000e+00 \
  xpart=1.0000e+00     clc=1.0000e-15     cle=6.0000e-01 \
   noff=1.0000e+00  voffcv=0.0000e+00 \
   rdsw=1.3900e+03 \
   cdsc=0.0000e+00   cdscb=-1.500e-03   cdscd=0.0000e+00 \
   prwb=-6.740e-02    prwg=0.0000e+00     cit=0.0000e+00 \
tox=1.5160e-08 \
  ngate=0.0000e+00 \
    nlx=2.2830e-07 \
     xl=0.0000e+00      xw=0.0000e+00 \
     af=1.3580e+00      kf=3.4460e-26      ef=1.0000e+00 \
   noia=1.7020e+20    noib=5.4630e+05    noic=-1.400e-11 \
     rd=0.0000e+00      rs=0.0000e+00     rsh=7.9000e+01 \
   minr=1.000e-03 \
    rdc=0.0000e+00     rsc=0.0000e+00 lint=1.2250e-07 \
wint=1.6230e-07   ldif=0.000e+00    hdif=6.0000e-07 \
     xj=3.0000e-07      js=5.1000e-07 \
      n=1.0000e+00 \
  dskip=no          tlev=0           tlevc=0         \
    jsw=6.0000e-13 \
     cj=8.3000e-04    cjsw=2.5000e-10 \
     fc=0.0000e+00    fcsw=0.000e+00 \
     mj=3.4000e-01    mjsw=2.3000e-01 \
     pb=6.9000e-01    pbsw=6.9000e-01     xti=2.0260e+00
ends modnm

// ----------------------------------------------------------------------

// ----------------------------------------------------------------------
// Owner: austriamicrosystems
// HIT-Kit: Digital
// ************************ SIMULATION PARAMETERS ************************
//  ----------------------------------------------------------------------
//  format    : Spectre (Spectre Direct)
//  model     : MOS BSIM3v3
//  process   : C35
//  revision  : 5.0;
//  extracted : B27167L1W5C45; 15-04-2007; bse (5866)
//  doc#      : Eng-182 REV_6
//  ----------------------------------------------------------------------
//                    TYPICAL MEAN WORST NOISE CONDITION
//
//  ----------------------------------------------------------------------
//
inline subckt modnl ( d g s b )
parameters w=1.0e-6 l=1.0e-6 nrd=0.0 nrs=0.0 ad=0.0 as=0.0 pd=0.0 ps=0.0 ng=1
+ ws= w
+ ls= l
+ shk=1
+ dvthmat=(mv_modnl)*(0.67e-08/sqrt(ls*ws*ng)) dumat=(mu_modnl)*(4.9e-9/sqrt(ls*ws*ng))
//
if (modnl==1)
modnl ( d g s b ) mosinsub w=ws l=ls nrd=8.0000e-07/ws nrs=8.0000e-07/ws ad=ad as=as pd=pd ps=ps m=ng
else
modnl ( d s ) resistor r=1e30
notvalid paramtest errorif=(modnl==0) \
message="
***************************************************
*
* nmosl is not valid in selected process option.
*
***************************************************"
model mosinsub bsim3v3 version=3.2400e+00  type=n  capmod=2.0000e+00 \
 mobmod=1.0000e+00  nqsmod=0.0000e+00  noimod=3.0000e+00 \
   vbox=1.000e+03      k1=5.4000e-01 \
     k2=0.0000e+00      k3=7.6040e+00     k3b=0.0000e+00 \
    nch=2.1870e+17 vth0=4.2200e-01+dvthmat \
   voff=-8.000e-02    dvt0=1.2570e+01    dvt1=8.1290e-01 \
   dvt2=2.2200e-15    keta=-2.800e-03 \
 pscbe1=1.0000e+30  pscbe2=1.0000e-06 \
 alpha0=1.9000e-06  alpha1=1.0000e+00   beta0=2.0000e+01 \
  dvt0w=0.0000e+00   dvt1w=1.6970e+06   dvt2w=2.5060e-01 \
     ua=1.0000e-12      ub=2.1880e-18      uc=7.2440e-11 \
u0=4.4700e+02+(4.4700e+02)*dumat \
   dsub=5.0000e-01    eta0=5.1580e-02    etab=-6.600e-02 \
nfactor=1.0000e+00 \
     em=4.1000e+07    pclm=1.2650e+00 \
  drout=5.0000e-01 \
     a0=1.7080e+00      a1=0.0000e+00      a2=1.0000e+00 \
   pvag=3.1500e-01    vsat=9.4190e+04     ags=3.1620e-01      b0=2.6240e-08      b1=0.0000e+00 \
  delta=1.0000e-03 pdiblcb=3.6000e-01 \
pdiblc1=1.2970e-01 pdiblc2=1.9500e-03 \
     w0=2.5000e-06 \
    dlc=3.0000e-08 \
    dwc=9.5120e-08     dwb=0.0000e+00     dwg=-7.686e-09 \
     ll=6.3200e-15      lw=0.0000e+00     lwl=0.0000e+00 \
    lln=1.0000e+00     lwn=1.0000e+00      wl=0.0000e+00 \
     ww=-2.855e-14     wwl=-4.365e-21     wln=1.0000e+00 \
    wwn=1.0000e+00 \
     at=1.0000e+04     ute=-1.700e+00 \
    kt1=-3.400e-01     kt2=-4.840e-02    kt1l=0.0000e+00 \
    ua1=0.0000e+00     ub1=0.0000e+00     uc1=0.0000e+00 \
    prt=0.0000e+00 \
   cgso=1.2000e-11    cgdo=1.2000e-11    cgbo=1.1000e-10 \
   cgdl=3.5000e-10    cgsl=3.5000e-10  ckappa=1.7010e+00 \
     cf=0.0000e+00     elm=5.0000e+00 \
  xpart=1.0000e+00     clc=1.0000e-15     cle=6.0000e-01 \
\
   rdsw=4.4670e+02 \
   cdsc=1.0000e-09   cdscb=0.0000e+00   cdscd=0.0000e+00 \
   prwb=0.0000e+00    prwg=1.9050e-02     cit=0.0000e+00 \
tox=7.6700e-09 \
  ngate=0.0000e+00 \
    nlx=1.4300e-07 \
     xl=0.0000e+00      xw=0.0000e+00 \
     af=1.4940e+00      kf=6.9860e-26      ef=1.0000e+00 \
   noia=9.8640e+19    noib=1.7020e+05    noic=-2.723e-12 \
     rd=0.0000e+00      rs=0.0000e+00     rsh=7.5000e+01 \
   minr=1.000e-03 \
    rdc=0.0000e+00     rsc=0.0000e+00 lint=-6.902e-09 \
wint=9.5120e-08   ldif=0.000e+00    hdif=8.0000e-07 \
     xj=3.0000e-07      js=5.1000e-07 \
      n=1.0000e+00 \
  dskip=no          tlev=0           tlevc=0         \
    jsw=6.0000e-13 \
     cj=8.3000e-04    cjsw=2.5000e-10 \
     fc=0.0000e+00    fcsw=0.000e+00 \
     mj=3.4000e-01    mjsw=2.3000e-01 \
     pb=6.9000e-01    pbsw=6.9000e-01     xti=2.0300e+00
ends modnl

// ----------------------------------------------------------------------

// ----------------------------------------------------------------------
// Owner: austriamicrosystems
// HIT-Kit: Digital
// ************************ SIMULATION PARAMETERS ************************
//  ----------------------------------------------------------------------
//  format    : Spectre (Spectre Direct)
//  model     : MOS BSIM3v3
//  process   : C35
//  revision  : 5.0;
//  extracted : B27167L1W5C45; 15-04-2007; bse (5866)
//  doc#      : Eng-182 REV_6
//  ----------------------------------------------------------------------
//                    TYPICAL MEAN WORST NOISE CONDITION
//
//  ----------------------------------------------------------------------
//
inline subckt modnml ( d g s b )
parameters w=1.0e-6 l=1.0e-6 nrd=0.0 nrs=0.0 ad=0.0 as=0.0 pd=0.0 ps=0.0 ng=1
+ ws= w
+ ls= l
+ shk=1
+ dvthmat=(mv_modnml)*(0.95e-08/sqrt(ls*ws*ng)) dumat=(mu_modnml)*(3.5e-9/sqrt(ls*ws*ng))
//
if (modnml==1)
modnml ( d g s b ) mosinsub w=ws l=ls nrd=6.0000e-07/ws nrs=6.0000e-07/ws ad=ad as=as pd=pd ps=ps m=ng
else
modnml ( d s ) resistor r=1e30
notvalid paramtest errorif=(modnml==0) \
message="
***************************************************
*
* nmosml is not valid in selected process option.
*
***************************************************"
model mosinsub bsim3v3 version=3.2400e+00  type=n  capmod=2.0000e+00 \
 mobmod=1.0000e+00  nqsmod=0.0000e+00  noimod=3.0000e+00 \
   vbox=1.000e+03      k1=9.8000e-01 \
     k2=0.0000e+00      k3=-1.456e+00     k3b=-7.244e-01 \
    nch=1.4460e+17 vth0=5.7940e-01+dvthmat \
   voff=-8.684e-02    dvt0=1.6010e+01    dvt1=1.0610e+00 \
   dvt2=4.5970e-02    keta=1.9180e-02 \
 pscbe1=1.0000e+30  pscbe2=1.0000e-06 \
 alpha0=1.6220e-08  alpha1=1.3800e-01   beta0=2.1000e+01 \
  dvt0w=0.0000e+00   dvt1w=3.0990e+06   dvt2w=4.5170e-02 \
     ua=1.0000e-12      ub=2.2910e-18      uc=6.9180e-11 \
u0=4.9000e+02+(4.9000e+02)*dumat \
   dsub=5.0000e-01    eta0=5.1290e-02    etab=-5.126e-03 \
nfactor=9.6050e-01 \
     em=4.1000e+07    pclm=1.1380e+00 \
  drout=5.0000e-01 \
     a0=1.0460e+00      a1=0.0000e+00      a2=1.0000e+00 \
   pvag=5.0000e-02    vsat=8.4420e+04     ags=1.2000e-01      b0=0.0000e+00      b1=0.0000e+00 \
  delta=1.8640e-03 pdiblcb=9.7980e-01 \
pdiblc1=6.1030e-06 pdiblc2=7.2440e-04 \
     w0=3.3160e-08 \
    dlc=1.0000e-07 \
    dwc=1.1660e-07     dwb=5.8200e-09     dwg=-1.000e-09 \
     ll=-9.793e-15      lw=0.0000e+00     lwl=0.0000e+00 \
    lln=1.0000e+00     lwn=1.0000e+00      wl=0.0000e+00 \
     ww=-4.017e-14     wwl=-1.380e-21     wln=1.0000e+00 \
    wwn=1.0000e+00 \
     at=4.3550e+04     ute=-1.720e+00 \
    kt1=-4.500e-01     kt2=-6.560e-02    kt1l=0.0000e+00 \
    ua1=2.7540e-10     ub1=0.0000e+00     uc1=0.0000e+00 \
    prt=2.0000e+02 \
   cgso=1.0000e-12    cgdo=1.0000e-12    cgbo=1.1000e-10 \
   cgdl=4.3400e-10    cgsl=4.3400e-10  ckappa=1.9040e+00 \
     cf=0.0000e+00     elm=5.0000e+00 \
  xpart=1.0000e+00     clc=1.0000e-15     cle=6.0000e-01 \
\
   rdsw=1.1940e+03 \
   cdsc=2.4000e-04   cdscb=-7.468e-04   cdscd=0.0000e+00 \
   prwb=5.2110e-02    prwg=-5.443e-02     cit=0.0000e+00 \
tox=1.5700e-08 \
  ngate=1.0000e+00 \
    nlx=2.3690e-07 \
     xl=0.0000e+00      xw=0.0000e+00 \
     af=1.4000e+00      kf=3.7700e-26      ef=1.0000e+00 \
   noia=1.5360e+20    noib=3.5840e+05    noic=-1.304e-11 \
     rd=0.0000e+00      rs=0.0000e+00     rsh=7.9000e+01 \
   minr=1.000e-03 \
    rdc=0.0000e+00     rsc=0.0000e+00 lint=1.1900e-07 \
wint=1.1660e-07   ldif=0.000e+00    hdif=6.0000e-07 \
     xj=3.0000e-07      js=5.1000e-07 \
      n=1.0000e+00 \
  dskip=no          tlev=0           tlevc=0         \
    jsw=6.0000e-13 \
     cj=8.3000e-04    cjsw=2.5000e-10 \
     fc=0.0000e+00    fcsw=0.000e+00 \
     mj=3.4000e-01    mjsw=2.3000e-01 \
     pb=6.9000e-01    pbsw=6.9000e-01     xti=2.0300e+00
ends modnml

// ----------------------------------------------------------------------
// ----------------------------------------------------------------------
// Owner: austriamicrosystems
// HIT-Kit: Digital
// ************************ SIMULATION PARAMETERS ************************
//  ----------------------------------------------------------------------
//  format    : Spectre (Spectre Direct)
//  model     : MOS BSIM3v3
//  process   : C35
//  revision  : 4.1;
//  extracted : C64685 ; 2002-12; ese(5487)
//  doc#      : ENG-182 REV_6
//  ----------------------------------------------------------------------
//                    TYPICAL MEAN WORST NOISE CONDITION
//
//  ----------------------------------------------------------------------
//
inline subckt modpm ( d g s b )
parameters w=1.0e-6 l=1.0e-6 nrd=0.0 nrs=0.0 ad=0.0 as=0.0 pd=0.0 ps=0.0 ng=1
+ ws= w
+ ls= l
+ shk=1
+ dvthmat=(mv_modpm)*(1.5e-08/sqrt(ls*ws*ng)) dumat=(mu_modpm)*(7.1e-9/sqrt(ls*ws*ng))
//
if (modpm==1)
modpm ( d g s b ) mosinsub w=ws l=ls nrd=nrd nrs=nrs ad=ad as=as pd=pd ps=ps m=ng
else
modpm ( d s ) resistor r=1e30
notvalid paramtest errorif=(modpm==0) \
message="
***************************************************
*
* pmosm is not valid in selected process option.
*
***************************************************"
model mosinsub bsim3v3 version=3.2400e+00  type=p  capmod=2.0000e+00 \
 mobmod=1.0000e+00  nqsmod=0.0000e+00  noimod=3 \
   vbox=1.000e+03      k1=5.4907e-01 \
     k2=4.6395e-02      k3=8.3170e+00     k3b=-1.479e+00 \
    nch=8.4790e+16 vth0=-1.011e+00+dvthmat \
   voff=-1.148e-01    dvt0=5.3990e-01    dvt1=4.1120e-01 \
   dvt2=-9.479e-02    keta=3.0100e-02 \
 pscbe1=1.0000e+30  pscbe2=1.0000e-06 \
 alpha0=2.7100e-07  alpha1=1.9100e+00   beta0=3.4770e+01 \
  dvt0w=8.0990e-01   dvt1w=1.4800e+05   dvt2w=4.4040e-02 \
     ua=1.8000e-12      ub=2.2180e-18      uc=-7.278e-11 \
u0=1.3730e+02+(1.3730e+02)*dumat \
   dsub=5.0000e-01    eta0=9.7360e-02    etab=-2.948e-02 \
nfactor=7.0460e-01 \
     em=4.1000e+07    pclm=4.3950e+00 \
  drout=5.0000e-01 \
     a0=1.3860e+00      a1=0.0000e+00      a2=1.0000e+00 \
   pvag=0.0000e+00    vsat=1.4360e+05     ags=1.3640e-01      b0=1.9910e-08      b1=0.0000e+00 \
  delta=1.0000e-02 pdiblcb=1.0000e+00 \
pdiblc1=2.0370e-02 pdiblc2=1.0000e-20 \
     w0=1.0000e-10 \
    dlc=2.5000e-08 \
    dwc=6.2030e-08     dwb=0.0000e+00     dwg=0.0000e+00 \
     ll=0.000e+00      lw=0.000e+00     lwl=0.000e+00 \
    lln=1.000e+00     lwn=1.000e+00      wl=0.0000e+00 \
     ww=-9.750e-16     wwl=-1.787e-21     wln=1.0000e+00 \
    wwn=1.0400e+00 \
     at=3.3000e+04     ute=-1.300e+00 \
    kt1=-6.003e-01     kt2=2.2000e-02    kt1l=0.0000e+00 \
    ua1=0.0000e+00     ub1=0.0000e+00     uc1=0.0000e+00 \
    prt=0.0000e+00 \
   cgso=9.1000e-11    cgdo=9.1000e-11    cgbo=1.1000e-10 \
   cgdl=6.0000e-11    cgsl=6.0000e-11  ckappa=6.0000e-01 \
     cf=0.0000e+00     elm=5.0000e+00 \
  xpart=1.0000e+00     clc=1.0000e-15     cle=6.0000e-01 \
   noff=1.0000e+00  voffcv=0.0000e+00 \
   rdsw=1.6230e+03 \
   cdsc=1.2140e-03   cdscb=2.9450e-04   cdscd=0.0000e+00 \
   prwb=-4.521e-01    prwg=0.0000e+00     cit=5.2590e-05 \
tox=1.4500e-08 \
  ngate=0.0000e+00 \
    nlx=2.2310e-07 \
     xl=0.0000e+00      xw=0.0000e+00 \
     af=1.5640e+00      kf=4.8520e-26      ef=1.0000e+00 \
   noia=1.8720e+18    noib=3.4540e+04    noic=1.2460e-12 \
     rd=0.0000e+00      rs=0.0000e+00     rsh=1.3000e+02 \
   minr=1.000e-03 \
    rdc=0.0000e+00     rsc=0.0000e+00 lint=-8.504e-08 \
wint=6.2030e-08   ldif=0.000e+00    hdif=6.0000e-07 \
     xj=3.0000e-07      js=2.8000e-07 \
      n=1.0000e+00 \
  dskip=no          tlev=0           tlevc=0         \
    jsw=3.7000e-13 \
     cj=1.3600e-03    cjsw=3.5000e-10 \
     fc=0.0000e+00    fcsw=0.000e+00 \
     mj=5.4000e-01    mjsw=4.6000e-01 \
     pb=1.0200e+00    pbsw=1.0200e+00     xti=1.9700e+00
ends modpm

// ----------------------------------------------------------------------

// ----------------------------------------------------------------------
// Owner: austriamicrosystems
// HIT-Kit: Digital
// ************************ SIMULATION PARAMETERS ************************
//  ----------------------------------------------------------------------
//  format    : Spectre (Spectre Direct)
//  model     : MOS BSIM3v3
//  process   : C35
//  revision  : 5.0;
//  extracted : B27167L1W5C45; 15-04-2007; bse (5866)
//  doc#      : Eng-182 REV_6
//  ----------------------------------------------------------------------
//                    TYPICAL MEAN WORST NOISE CONDITION
//
//  ----------------------------------------------------------------------
//
inline subckt modpml ( d g s b )
parameters w=1.0e-6 l=1.0e-6 nrd=0.0 nrs=0.0 ad=0.0 as=0.0 pd=0.0 ps=0.0 ng=1
+ ws= w
+ ls= l
+ shk=1
+ dvthmat=(mv_modpml)*(1.8e-08/sqrt(ls*ws*ng)) dumat=(mu_modpml)*(6.3e-9/sqrt(ls*ws*ng))
//
if (modpml==1)
modpml ( d g s b ) mosinsub w=ws l=ls nrd=6.0000e-07/ws nrs=6.0000e-07/ws ad=ad as=as pd=pd ps=ps m=ng
else
modpml ( d s ) resistor r=1e30
notvalid paramtest errorif=(modpml==0) \
message="
***************************************************
*
* pmosml is not valid in selected process option.
*
***************************************************"
model mosinsub bsim3v3 version=3.2400e+00  type=p  capmod=2.0000e+00 \
 mobmod=1.0000e+00  nqsmod=0.0000e+00  noimod=3.0000e+00 \
   vbox=1.000e+03      k1=6.7600e-01 \
     k2=-4.000e-03      k3=1.7420e+01     k3b=-1.738e+00 \
    nch=6.7780e+16 vth0=-6.880e-01+dvthmat \
   voff=-1.960e-01    dvt0=1.0000e+00    dvt1=4.2050e-01 \
   dvt2=-4.410e-02    keta=6.0000e-03 \
 pscbe1=1.0000e+30  pscbe2=1.0000e-06 \
 alpha0=1.3000e-07  alpha1=3.3320e-02   beta0=2.4820e+01 \
  dvt0w=5.7320e-01   dvt1w=2.8750e+05   dvt2w=1.6680e-01 \
     ua=3.3110e-09      ub=1.0000e-19      uc=-8.710e-11 \
u0=2.3600e+02+(2.3600e+02)*dumat \
   dsub=5.0000e-01    eta0=1.2500e-01    etab=-3.726e-04 \
nfactor=1.0210e+00 \
     em=4.1000e+07    pclm=2.5000e+00 \
  drout=5.0000e-01 \
     a0=1.1720e+00      a1=-1.581e-01      a2=1.0000e+00 \
   pvag=0.0000e+00    vsat=1.5690e+05     ags=1.4450e-01      b0=6.1800e-08      b1=0.0000e+00 \
  delta=2.9180e-02 pdiblcb=8.4520e-01 \
pdiblc1=1.1270e-02 pdiblc2=1.2500e-03 \
     w0=1.3800e-06 \
    dlc=4.5000e-08 \
    dwc=1.2300e-07     dwb=5.5110e-09     dwg=-5.171e-09 \
     ll=0.0000e+00      lw=0.0000e+00     lwl=0.0000e+00 \
    lln=1.0000e+00     lwn=1.0000e+00      wl=0.0000e+00 \
     ww=-4.460e-14     wwl=0.0000e+00     wln=1.0000e+00 \
    wwn=1.0000e+00 \
     at=3.0000e+03     ute=-1.628e+00 \
    kt1=-6.603e-01     kt2=-8.840e-02    kt1l=0.0000e+00 \
    ua1=-2.399e-09     ub1=0.0000e+00     uc1=0.0000e+00 \
    prt=0.0000e+00 \
   cgso=6.4000e-11    cgdo=6.4000e-11    cgbo=1.1000e-10 \
   cgdl=1.6000e-10    cgsl=1.6000e-10  ckappa=1.4370e+00 \
     cf=0.0000e+00     elm=5.0000e+00 \
  xpart=1.0000e+00     clc=1.0000e-15     cle=6.0000e-01 \
\
   rdsw=6.3530e+02 \
   cdsc=1.4540e-04   cdscb=-2.792e-05   cdscd=0.0000e+00 \
   prwb=-3.097e-01    prwg=0.0000e+00     cit=0.0000e+00 \
tox=1.5700e-08 \
  ngate=1.0000e+00 \
    nlx=2.9510e-07 \
     xl=0.0000e+00      xw=0.0000e+00 \
     af=1.4710e+00      kf=1.3230e-26      ef=1.0000e+00 \
   noia=1.1970e+19    noib=2.6610e+04    noic=6.7840e-13 \
     rd=0.0000e+00      rs=0.0000e+00     rsh=1.3000e+02 \
   minr=1.000e-03 \
    rdc=0.0000e+00     rsc=0.0000e+00 lint=-7.553e-08 \
wint=1.2300e-07   ldif=0.000e+00    hdif=6.0000e-07 \
     xj=3.0000e-07      js=2.8000e-07 \
      n=1.0000e+00 \
  dskip=no          tlev=0           tlevc=0         \
    jsw=3.7000e-13 \
     cj=1.3600e-03    cjsw=3.5000e-10 \
     fc=0.0000e+00    fcsw=0.000e+00 \
     mj=5.4000e-01    mjsw=4.6000e-01 \
     pb=1.0200e+00    pbsw=1.0200e+00     xti=1.9700e+00
ends modpml

// ----------------------------------------------------------------------
//----------------------------------------------------------------------
//************************* SIMULATION PARAMETERS ************************
// ----------------------------------------------------------------------
// format    : Spectre ( Spectre Direct )
// model     : DIODE
// process   : C35
// revision  : 4.0;
// extracted : B10866 ; 2002-12; ese(5487)
// doc#      : ENG-182 REV_6
// ----------------------------------------------------------------------
//                         TYPICAL MEAN CONDITION
// ----------------------------------------------------------------------
// TERMINALS: A=anode=P-region C=cathode=N-region
// VARIABLES: M (mulitiplier), AREA [m^2], PERI [m].
// NOTE: The role of a protection DIODE is to conduct ESD current to VDD
// (or from VSS). This forward bias is NOT modelled, only leakage current
// and capacitance during normal operation. Any inductive load etc that
// will give forward bias, must be limited by other components to within
// Operating Conditions, otherwise parasitic bipolar action can occur.
//
// Parameters: area perim
//
inline subckt nd ( a c )
parameters area=1.0e-12 perimeter=1.0e-6
//
if (subdiode==1)
nd ( a c ) diodeinsub area=area perim=perimeter region=off
else
nd ( a c ) resistor r=1e30
notvalid paramtest errorif=(subdiode==0) \
message="
***************************************************
*
* subdiode is not valid in selected process option.
*
***************************************************"
model diodeinsub diode level=1 dskip=no \
     is=5.1000e-07     isw=6.0000e-13       n=1.0000e+00      ns=1.0000e+00 \
   minr=0.100e+00    imax=(1.000e+00/area) \
    cjo=8.4000e-04       m=3.4000e-01      vj=6.9000e-01      tt=0.000e+00 \
    xti=2.0260e+00 \
   cjsw=2.5000e-10    mjsw=2.3000e-01    vjsw=6.9000e-01      fc=0.000e+00 \
     af=1.000e+00      kf=0.000e+00
ends nd
// ----------------------------------------------------------------------
// Owner: austriamicrosystems
// HIT-Kit: Digital
// ************************ SIMULATION PARAMETERS ************************
//  ----------------------------------------------------------------------
//  format    : Spectre (Spectre Direct)
//  model     : MOS BSIM3v3
//  process   : C35
//  revision  : 4.1;
//  extracted : C64685 ; 2002-12; ese(5487)
//  doc#      : ENG-182 REV_6
//  ----------------------------------------------------------------------
//                    TYPICAL MEAN WORST NOISE CONDITION
//
//  ----------------------------------------------------------------------
//
inline subckt modp ( d g s b )
parameters w=1.0e-6 l=1.0e-6 nrd=0.0 nrs=0.0 ad=0.0 as=0.0 pd=0.0 ps=0.0 ng=1
+ ws= w
+ ls= l
+ shk=1
+ dvthmat=(mv_modp)*(1.03e-08/sqrt(ls*ws*ng)) dumat=(mu_modp)*(7.1e-9/sqrt(ls*ws*ng))
//
if (modp==1)
modp ( d g s b ) mosinsub w=ws l=ls nrd=nrd nrs=nrs ad=ad as=as pd=pd ps=ps m=ng
else
modp ( d s ) resistor r=1e30
notvalid paramtest errorif=(modp==0) \
message="
***************************************************
*
* pmos is not valid in selected process option.
*
***************************************************"
model mosinsub bsim3v3 version=3.2400e+00  type=p  capmod=2.0000e+00 \
 mobmod=1.0000e+00  nqsmod=0.0000e+00  noimod=3 \
   vbox=1.000e+03      k1=5.9959e-01 \
     k2=-6.038e-02      k3=1.1030e+01     k3b=-7.580e-01 \
    nch=9.2400e+16 vth0=-6.915e-01+dvthmat \
   voff=-1.170e-01    dvt0=1.6500e+00    dvt1=3.8680e-01 \
   dvt2=1.6590e-02    keta=-1.440e-02 \
 pscbe1=1.0000e+30  pscbe2=1.0000e-06 \
 alpha0=1.0000e-09  alpha1=1.5000e+00   beta0=3.2500e+01 \
  dvt0w=1.8790e-01   dvt1w=7.3350e+04   dvt2w=-6.312e-03 \
     ua=5.3940e-10      ub=1.0530e-18      uc=1.0000e-20 \
u0=1.4820e+02+(1.4820e+02)*dumat \
   dsub=5.0000e-01    eta0=2.4800e-01    etab=-3.917e-03 \
nfactor=1.2140e+00 \
     em=4.1000e+07    pclm=3.1840e+00 \
  drout=5.0000e-01 \
     a0=5.8500e-01      a1=0.0000e+00      a2=1.0000e+00 \
   pvag=0.0000e+00    vsat=1.1580e+05     ags=2.4680e-01      b0=8.8320e-08      b1=0.0000e+00 \
  delta=1.0000e-02 pdiblcb=1.0000e+00 \
pdiblc1=1.0000e-04 pdiblc2=1.0000e-20 \
     w0=1.0000e-10 \
    dlc=2.4500e-08 \
    dwc=3.4490e-08     dwb=0.0000e+00     dwg=0.0000e+00 \
     ll=0.000e+00      lw=0.000e+00     lwl=0.000e+00 \
    lln=1.000e+00     lwn=1.000e+00      wl=0.0000e+00 \
     ww=1.8940e-16     wwl=-1.981e-21     wln=1.0000e+00 \
    wwn=1.0400e+00 \
     at=3.3000e+04     ute=-1.300e+00 \
    kt1=-5.403e-01     kt2=2.2000e-02    kt1l=0.0000e+00 \
    ua1=0.0000e+00     ub1=0.0000e+00     uc1=0.0000e+00 \
    prt=0.0000e+00 \
   cgso=8.6000e-11    cgdo=8.6000e-11    cgbo=1.1000e-10 \
   cgdl=1.0800e-10    cgsl=1.0800e-10  ckappa=6.0000e-01 \
     cf=0.0000e+00     elm=5.0000e+00 \
  xpart=1.0000e+00     clc=1.0000e-15     cle=6.0000e-01 \
   noff=1.0000e+00  voffcv=0.0000e+00 \
   rdsw=1.0330e+03 \
   cdsc=2.5890e-03   cdscb=2.9430e-04   cdscd=4.3700e-04 \
   prwb=-9.731e-02    prwg=1.4770e-01     cit=0.0000e+00 \
tox=7.7540e-09 \
  ngate=0.0000e+00 \
    nlx=1.7700e-07 \
     xl=0.0000e+00      xw=0.0000e+00 \
     af=1.4050e+00      kf=1.8270e-26      ef=1.0000e+00 \
   noia=7.0910e+18    noib=6.0740e+04    noic=3.7790e-13 \
     rd=0.0000e+00      rs=0.0000e+00     rsh=1.2900e+02 \
   minr=1.000e-03 \
    rdc=0.0000e+00     rsc=0.0000e+00 lint=-7.130e-08 \
wint=3.4490e-08   ldif=0.000e+00    hdif=8.0000e-07 \
     xj=3.0000e-07      js=2.8000e-07 \
      n=1.0000e+00 \
  dskip=no          tlev=0           tlevc=0         \
    jsw=3.7000e-13 \
     cj=1.3600e-03    cjsw=3.5000e-10 \
     fc=0.0000e+00    fcsw=0.000e+00 \
     mj=5.4000e-01    mjsw=4.6000e-01 \
     pb=1.0200e+00    pbsw=1.0200e+00     xti=1.9730e+00
ends modp

// ----------------------------------------------------------------------

// ----------------------------------------------------------------------
// Owner: austriamicrosystems
// HIT-Kit: Digital
// ************************ SIMULATION PARAMETERS ************************
//  ----------------------------------------------------------------------
//  format    : Spectre (Spectre Direct)
//  model     : MOS BSIM3v3
//  process   : C35
//  revision  : 5.0;
//  extracted : B27167L1W5C45; 15-04-2007; bse (5866)
//  doc#      : Eng-182 REV_6
//  ----------------------------------------------------------------------
//                    TYPICAL MEAN WORST NOISE CONDITION
//
//  ----------------------------------------------------------------------
//
inline subckt modpl ( d g s b )
parameters w=1.0e-6 l=1.0e-6 nrd=0.0 nrs=0.0 ad=0.0 as=0.0 pd=0.0 ps=0.0 ng=1
+ ws= w
+ ls= l
+ shk=1
+ dvthmat=(mv_modpl)*(1.24e-08/sqrt(ls*ws*ng)) dumat=(mu_modpl)*(5.7e-9/sqrt(ls*ws*ng))
//
if (modpl==1)
modpl ( d g s b ) mosinsub w=ws l=ls nrd=8.0000e-07/ws nrs=8.0000e-07/ws ad=ad as=as pd=pd ps=ps m=ng
else
modpl ( d s ) resistor r=1e30
notvalid paramtest errorif=(modpl==0) \
message="
***************************************************
*
* pmosl is not valid in selected process option.
*
***************************************************"
model mosinsub bsim3v3 version=3.2400e+00  type=p  capmod=2.0000e+00 \
 mobmod=1.0000e+00  nqsmod=0.0000e+00  noimod=3.0000e+00 \
   vbox=1.000e+03      k1=6.8800e-01 \
     k2=-7.790e-02      k3=5.2610e+01     k3b=7.2440e+00 \
    nch=7.8380e+16 vth0=-5.240e-01+dvthmat \
   voff=-2.280e-01    dvt0=1.0460e+00    dvt1=3.9190e-01 \
   dvt2=1.9100e-03    keta=-2.400e-03 \
 pscbe1=1.0000e+30  pscbe2=1.0000e-06 \
 alpha0=1.1750e-08  alpha1=1.0000e-03   beta0=1.9580e+01 \
  dvt0w=1.0000e+00   dvt1w=5.3000e+06   dvt2w=9.5620e-02 \
     ua=1.0000e-12      ub=1.9050e-18      uc=6.3100e-11 \
u0=1.4500e+02+(1.4500e+02)*dumat \
   dsub=5.0000e-01    eta0=1.9590e-01    etab=0.0000e+00 \
nfactor=1.5790e+00 \
     em=4.1000e+07    pclm=8.2410e-01 \
  drout=5.0000e-01 \
     a0=5.0000e-01      a1=0.0000e+00      a2=1.0000e+00 \
   pvag=0.0000e+00    vsat=9.8190e+04     ags=2.6300e-01      b0=6.0600e-08      b1=0.0000e+00 \
  delta=4.3330e-03 pdiblcb=9.6330e-01 \
pdiblc1=1.0000e-03 pdiblc2=1.3800e-03 \
     w0=1.9050e-06 \
    dlc=2.0000e-08 \
    dwc=7.2920e-08     dwb=1.6220e-08     dwg=0.0000e+00 \
     ll=0.0000e+00      lw=0.0000e+00     lwl=0.0000e+00 \
    lln=1.0000e+00     lwn=1.0000e+00      wl=0.0000e+00 \
     ww=-2.000e-14     wwl=0.0000e+00     wln=1.0000e+00 \
    wwn=1.0400e+00 \
     at=3.3000e+04     ute=-1.280e+00 \
    kt1=-5.577e-01     kt2=-6.560e-02    kt1l=0.0000e+00 \
    ua1=0.0000e+00     ub1=0.0000e+00     uc1=0.0000e+00 \
    prt=0.0000e+00 \
   cgso=5.6000e-11    cgdo=5.6000e-11    cgbo=1.1000e-10 \
   cgdl=2.4000e-10    cgsl=2.4000e-10  ckappa=5.6400e-01 \
     cf=0.0000e+00     elm=5.0000e+00 \
  xpart=1.0000e+00     clc=1.0000e-15     cle=6.0000e-01 \
\
   rdsw=2.0890e+03 \
   cdsc=1.3750e-03   cdscb=4.4880e-04   cdscd=1.9130e-04 \
   prwb=3.8020e-02    prwg=-1.047e-01     cit=0.0000e+00 \
tox=7.6600e-09 \
  ngate=1.0000e+00 \
    nlx=1.6220e-07 \
     xl=0.0000e+00      xw=0.0000e+00 \
     af=1.4690e+00      kf=1.2960e-26      ef=1.0000e+00 \
   noia=2.9220e+19    noib=1.7730e+04    noic=4.5200e-13 \
     rd=0.0000e+00      rs=0.0000e+00     rsh=1.2900e+02 \
   minr=1.000e-03 \
    rdc=0.0000e+00     rsc=0.0000e+00 lint=-1.285e-08 \
wint=7.2920e-08   ldif=0.000e+00    hdif=8.0000e-07 \
     xj=3.0000e-07      js=2.8000e-07 \
      n=1.0000e+00 \
  dskip=no          tlev=0           tlevc=0         \
    jsw=3.7000e-13 \
     cj=1.3600e-03    cjsw=3.5000e-10 \
     fc=0.0000e+00    fcsw=0.000e+00 \
     mj=5.4000e-01    mjsw=4.6000e-01 \
     pb=1.0200e+00    pbsw=1.0200e+00     xti=1.9700e+00
ends modpl

// ----------------------------------------------------------------------
//----------------------------------------------------------------------
//************************* SIMULATION PARAMETERS ************************
// ----------------------------------------------------------------------
// format    : Spectre ( Spectre Direct )
// model     : DIODE
// process   : C35
// revision  : 4.1;
// extracted : C64685 ; 2002-12; ese(5487)
// doc#      : ENG-182 REV_6
// ----------------------------------------------------------------------
//                         TYPICAL MEAN CONDITION
// ----------------------------------------------------------------------
// TERMINALS: A=anode=P-region C=cathode=N-region
// VARIABLES: M (mulitiplier), AREA [m^2], PERI [m].
// NOTE: The role of a protection DIODE is to conduct ESD current to VDD
// (or from VSS). This forward bias is NOT modelled, only leakage current
// and capacitance during normal operation. Any inductive load etc that
// will give forward bias, must be limited by other components to within
// Operating Conditions, otherwise parasitic bipolar action can occur.
//
// Parameters: area perim
//
inline subckt pd ( a c )
parameters area=1.0e-12 perimeter=1.0e-6
//
if (welldiode==1)
pd ( a c ) diodeinsub area=area perim=perimeter region=off
else
pd ( a c ) resistor r=1e30
notvalid paramtest errorif=(welldiode==0) \
message="
***************************************************
*
* welldiode is not valid in selected process option.
*
***************************************************"
model diodeinsub diode level=1 dskip=no \
     is=2.8000e-07     isw=3.7000e-13       n=1.0000e+00      ns=1.0000e+00 \
   minr=0.100e+00    imax=(1.000e+00/area) \
    cjo=1.3600e-03       m=5.4000e-01      vj=1.0200e+00      tt=0.000e+00 \
    xti=1.9730e+00 \
   cjsw=3.5000e-10    mjsw=4.6000e-01    vjsw=1.0200e+00      fc=0.000e+00 \
     af=1.000e+00      kf=0.000e+00
ends pd
// ----------------------------------------------------------------------
// Owner: austriamicrosystems
// HIT-Kit: Digital
// ************************ SIMULATION PARAMETERS ************************
//  ----------------------------------------------------------------------
//  format    : Spectre (Spectre Direct)
//  model     : MOS BSIM3v3
//  process   : C35
//  revision  : 4.1;
//  extracted : C35 B11004.L2; 2002-11; hhl(5481)
//  doc#      : Eng-182  REV_6.0
//  ----------------------------------------------------------------------
//                    TYPICAL MEAN WORST NOISE CONDITION
//  ----------------------------------------------------------------------
//  HV-TRANSISTOR
//  ----------------------------------------------------------------------
inline subckt modnmh ( d g s b )
// Parameters: w l nrd nrs ad as pd ps
parameters w=1.0e-6 l=1.0e-6 nrd=0.0 nrs=0.0 ad=0.0 as=0.0 pd=0.0 ps=0.0 mult=1
+ ws=w
+ ls=l
+ dvthmat=mv_modnmh*(1.03e-08/sqrt(ls*ws*mult)) dumat=mu_modnmh*(3.5e-9/sqrt(ls*ws*mult))
//
if (modnmh==1){
modnmh ( d1 g s b ) mosinsub w=ws l=ls nrd=0 nrs=6.0000e-07/ws ad=ad as=as pd=pd ps=ps
rd ( d1 d ) resistor r=(1.5470e+03*4.0000e-06/(ws)) tc1=6.2000e-03
}else
modnmh ( d s ) resistor r=1e30
notvalid paramtest errorif=(modnmh==0) \
message="
***************************************************
*
* nmosmh is not valid in selected process option.
*
***************************************************"
//
model mosinsub bsim3v3 version=3.1 type=n  capmod=2.0000e+00 \
 mobmod=1.0000e+00  nqsmod=0.0000e+00  noimod=3 \
   vbox=1.000e+03      k1=9.5409e-01 \
     k2=4.9101e-02      k3=-2.439e+00     k3b=4.0770e-01 \
    nch=2.0920e+17 vth0=6.4490e-01+dvthmat \
   voff=-4.948e-02    dvt0=4.9850e+01    dvt1=1.6830e+00 \
   dvt2=4.1260e-02    keta=-7.397e-02 \
 pscbe1=4.0000e+10  pscbe2=1.0000e-10 \
 alpha0=0.0000e+00   beta0=3.0000e+01 \
  dvt0w=0.0000e+00   dvt1w=0.0000e+00   dvt2w=0.0000e+00 \
     ua=1.0000e-12      ub=3.7680e-19      uc=6.3910e-12 \
u0=4.3940e+02+(4.3940e+02)*dumat \
   dsub=5.0000e-01    eta0=1.6160e-03    etab=-1.373e-02 \
nfactor=3.4550e-01 \
     em=4.1000e+07    pclm=1.0550e-01 \
  drout=5.0000e-01 \
     a0=2.1900e-01      a1=0.0000e+00      a2=1.0000e+00 \
   pvag=0.0000e+00    vsat=5.1290e+04     ags=9.4480e-02      b0=-3.629e-08      b1=0.0000e+00 \
  delta=3.3700e-03 pdiblcb=3.8720e-01 \
pdiblc1=1.0000e-10 pdiblc2=1.0000e-10 \
     w0=6.2890e-08 \
    dlc=8.9170e-08 \
    dwc=4.9380e-08     dwb=0.0000e+00     dwg=0.0000e+00 \
     ll=0.0000e+00      lw=0.0000e+00     lwl=0.0000e+00 \
    lln=1.0000e+00     lwn=1.0000e+00      wl=0.0000e+00 \
     ww=0.0000e+00     wwl=0.0000e+00     wln=1.0000e+00 \
    wwn=1.0000e+00 \
   tnom=2.7000e+01      at=3.3000e+04     ute=-1.760e+00 \
    kt1=-4.502e-01     kt2=2.2000e-02    kt1l=0.0000e+00 \
    ua1=0.0000e+00     ub1=0.0000e+00     uc1=0.0000e+00 \
    prt=0.0000e+00 \
   cgso=1.0800e-10    cgdo=1.0800e-10    cgbo=1.1000e-10 \
   cgdl=0.0000e+00    cgsl=0.0000e+00  ckappa=6.0000e-01 \
     cf=0.0000e+00     elm=5.0000e+00 \
  xpart=1.0000e+00     clc=1.0000e-15     cle=6.0000e-01 \
\
   rdsw=5.3040e+02 \
   cdsc=1.0000e-02   cdscb=0.0000e+00   cdscd=8.4480e-05 \
   prwb=0.0000e+00    prwg=0.0000e+00     cit=8.1220e-04 \
tox=1.5140e-08 \
  ngate=0.0000e+00 \
    nlx=1.5930e-07 \
     xl=-1.050e-06      xw=0.0000e+00 \
     af=1.3580e+00      kf=3.4460e-26      ef=1.0000e+00 \
   noia=1.7020e+20    noib=5.4630e+05    noic=-1.400e-11 \
     rd=0.0000e+00      rs=0.0000e+00     rsh=7.9460e+01 \
   minr=1.000e-03 \
    rdc=0.0000e+00     rsc=0.0000e+00 lint=8.9170e-08 \
wint=4.9380e-08   ldif=0.000e+00    hdif=6.0000e-07 \
     xj=3.0000e-07      js=5.1000e-07 \
      n=1.0000e+00 \
  dskip=no          tlev=0           tlevc=0         \
    jsw=6.0000e-13 \
     cj=8.0000e-05    cjsw=5.1000e-10 \
     fc=0.0000e+00    fcsw=0.000e+00 \
     mj=3.9000e-01    mjsw=2.7000e-01 \
     pb=5.3000e-01    pbsw=6.9000e-01     xti=2.0260e+00
ends modnmh
// ----------------------------------------------------------------------
// Owner: austriamicrosystems
// HIT-Kit: Digital
// ************************ SIMULATION PARAMETERS ************************
//  ----------------------------------------------------------------------
//  format    : Spectre (Spectre Direct)
//  model     : MOS BSIM3v3
//  process   : c35
//  revision  : 4.1;
//  extracted : Wafer B26654W01 2005/10/10 REVISION 4.0; wpc(5481)
//  doc#      : Eng-182  REV 6.0
//  ----------------------------------------------------------------------
//                    TYPICAL MEAN WORST NOISE CONDITION
//  ----------------------------------------------------------------------
//  HV-TRANSISTOR
//  ----------------------------------------------------------------------
inline subckt modnmhl ( d g s b )
// Parameters: w l nrd nrs ad as pd ps
parameters w=1.0e-6 l=1.0e-6 nrd=0.0 nrs=0.0 ad=0.0 as=0.0 pd=0.0 ps=0.0 mult=1
+ ws=w
+ ls=l
+ dvthmat=mv_modnmhl*(0.95e-08/sqrt(ls*ws*mult)) dumat=mu_modnmhl*(3.5e-9/sqrt(ls*ws*mult))
//
if (modnmhl==1){
modnmhl ( d1 g s b ) mosinsub w=ws l=ls nrd=0 nrs=8.0000e-07/ws ad=ad as=as pd=pd ps=ps
rd ( d1 d ) resistor r=(1.5080e+03*4.0000e-06/(ws+(0.0000e+00))) tc1=6.2000e-03
}else
modnmhl ( d s ) resistor r=1e30
notvalid paramtest errorif=(modnmhl==0) \
message="
***************************************************
*
* nmosmhl is not valid in selected process option.
*
***************************************************"
//
model mosinsub bsim3v3 version=3.1 type=n  capmod=2.0000e+00 \
 mobmod=1.0000e+00  nqsmod=0.0000e+00  noimod=3 \
   vbox=1.000e+03      k1=7.5005e-01 \
     k2=5.8718e-02      k3=0.0000e+00     k3b=0.0000e+00 \
    nch=1.4400e+17 vth0=4.9500e-01+dvthmat \
   voff=-5.565e-02    dvt0=0.0000e+00    dvt1=1.6830e+00 \
   dvt2=4.1260e-02    keta=-8.210e-02 \
 pscbe1=4.0000e+10  pscbe2=1.0000e-10 \
 alpha0=0.0000e+00   beta0=3.0000e+01 \
  dvt0w=0.0000e+00   dvt1w=0.0000e+00   dvt2w=0.0000e+00 \
     ua=2.2380e-10      ub=0.0000e+00      uc=-1.429e-11 \
u0=5.1100e+02+(5.1100e+02)*dumat \
   dsub=5.0000e-01    eta0=1.6160e-03    etab=-1.373e-02 \
nfactor=8.5500e-01 \
     em=4.1000e+07    pclm=1.0550e-01 \
  drout=5.0000e-01 \
     a0=4.7540e-02      a1=0.0000e+00      a2=1.0000e+00 \
   pvag=0.0000e+00    vsat=5.2060e+04     ags=-3.227e-01      b0=0.0000e+00      b1=0.0000e+00 \
  delta=1.5850e-02 pdiblcb=3.8720e-01 \
pdiblc1=1.0000e-10 pdiblc2=1.0000e-10 \
     w0=0.0000e+00 \
    dlc=0.0000e+00 \
    dwc=0.0000e+00     dwb=0.0000e+00     dwg=0.0000e+00 \
     ll=0.0000e+00      lw=0.0000e+00     lwl=0.0000e+00 \
    lln=1.0000e+00     lwn=1.0000e+00      wl=0.0000e+00 \
     ww=0.0000e+00     wwl=0.0000e+00     wln=1.0000e+00 \
    wwn=1.0000e+00 \
     at=3.3000e+04     ute=-1.720e+00 \
    kt1=-4.202e-01     kt2=2.2000e-02    kt1l=0.0000e+00 \
    ua1=0.0000e+00     ub1=0.0000e+00     uc1=0.0000e+00 \
    prt=0.0000e+00 \
   cgso=1.0000e-10    cgdo=1.0000e-10    cgbo=1.1000e-10 \
   cgdl=0.0000e+00    cgsl=0.0000e+00  ckappa=6.0000e-01 \
     cf=0.0000e+00     elm=5.0000e+00 \
  xpart=1.0000e+00     clc=1.0000e-15     cle=6.0000e-01 \
\
   rdsw=5.3040e+02 \
   cdsc=0.0000e+00   cdscb=0.0000e+00   cdscd=0.0000e+00 \
   prwb=0.0000e+00    prwg=0.0000e+00     cit=2.9310e-05 \
tox=1.5420e-08 \
  ngate=0.0000e+00 \
    nlx=1.5930e-07 \
     xl=0.0000e+00      xw=0.0000e+00 \
     af=1.4000e+00      kf=3.7700e-26      ef=1.0000e+00 \
   noia=1.5360e+20    noib=3.5840e+05    noic=-1.304e-11 \
     rd=0.0000e+00      rs=0.0000e+00     rsh=7.5000e+01 \
   minr=1.000e-03 \
    rdc=0.0000e+00     rsc=0.0000e+00 lint=6.0000e-07 \
wint=0.0000e+00   ldif=0.000e+00    hdif=8.0000e-07 \
     xj=3.0000e-07      js=5.1000e-07 \
      n=1.0000e+00 \
  dskip=no          tlev=0           tlevc=0         \
    jsw=6.0000e-13 \
     cj=8.3000e-04    cjsw=2.5000e-10 \
     fc=0.0000e+00    fcsw=0.000e+00 \
     mj=3.4000e-01    mjsw=2.3000e-01 \
     pb=6.9000e-01    pbsw=6.9000e-01     xti=2.0300e+00
ends modnmhl
// ----------------------------------------------------------------------
// Owner: austriamicrosystems
// HIT-Kit: Digital
// ************************ SIMULATION PARAMETERS ************************
//  ----------------------------------------------------------------------
//  format    : Spectre (Spectre Direct)
//  model     : MOS BSIM3v3
//  process   : C35
//  revision  : 4.1;
//  extracted : C35 B11004.L2; 2002-11; hhl(5481)
//  doc#      : Eng-182  REV_6.0
//  ----------------------------------------------------------------------
//                    TYPICAL MEAN WORST NOISE CONDITION
//  ----------------------------------------------------------------------
//  HV-TRANSISTOR
//  ----------------------------------------------------------------------
inline subckt modnh ( d g s b )
// Parameters: w l nrd nrs ad as pd ps
parameters w=1.0e-6 l=1.0e-6 nrd=0.0 nrs=0.0 ad=0.0 as=0.0 pd=0.0 ps=0.0 mult=1
+ ws=w
+ ls=l
+ dvthmat=mv_modnh*(0.67e-08/sqrt(ls*ws*mult)) dumat=mu_modnh*(4.9e-9/sqrt(ls*ws*mult))
//
if (modnh==1){
modnh ( d1 g s b ) mosinsub w=ws l=ls nrd=0 nrs=6.0000e-07/ws ad=ad as=as pd=pd ps=ps
rd ( d1 d ) resistor r=(1.3280e+03*4.0000e-06/(ws)) tc1=6.2000e-03
}else
modnh ( d s ) resistor r=1e30
notvalid paramtest errorif=(modnh==0) \
message="
***************************************************
*
* nmosh is not valid in selected process option.
*
***************************************************"
//
model mosinsub bsim3v3 version=3.1 type=n  capmod=2.0000e+00 \
 mobmod=1.0000e+00  nqsmod=0.0000e+00  noimod=3 \
   vbox=1.000e+03      k1=6.2697e-01 \
     k2=-4.966e-03      k3=-2.240e+00     k3b=6.9540e-01 \
    nch=2.2360e+17 vth0=4.4600e-01+dvthmat \
   voff=-5.090e-02    dvt0=4.9850e+01    dvt1=1.2960e+00 \
   dvt2=1.3110e-02    keta=-4.553e-02 \
 pscbe1=1.0000e+10  pscbe2=1.0240e-05 \
 alpha0=0.0000e+00   beta0=3.0000e+01 \
  dvt0w=0.0000e+00   dvt1w=0.0000e+00   dvt2w=0.0000e+00 \
     ua=1.0000e-30      ub=1.9490e-18      uc=1.2170e-10 \
u0=3.4270e+02+(3.4270e+02)*dumat \
   dsub=5.0000e-01    eta0=3.0750e-02    etab=-5.261e-02 \
nfactor=2.0340e-01 \
     em=4.1000e+07    pclm=2.9400e-01 \
  drout=5.0000e-01 \
     a0=1.8930e-01      a1=0.0000e+00      a2=1.0000e+00 \
   pvag=0.0000e+00    vsat=2.4020e+05     ags=1.2450e-01      b0=6.7900e-08      b1=0.0000e+00 \
  delta=1.7290e-02 pdiblcb=2.0670e-01 \
pdiblc1=3.0900e-02 pdiblc2=6.3750e-04 \
     w0=1.1450e-07 \
    dlc=6.0000e-07 \
    dwc=2.6050e-08     dwb=0.0000e+00     dwg=0.0000e+00 \
     ll=0.0000e+00      lw=0.0000e+00     lwl=0.0000e+00 \
    lln=1.0000e+00     lwn=1.0000e+00      wl=0.0000e+00 \
     ww=0.0000e+00     wwl=0.0000e+00     wln=1.0000e+00 \
    wwn=1.0000e+00 \
   tnom=2.7000e+01      at=3.3000e+04     ute=-1.800e+00 \
    kt1=-3.302e-01     kt2=2.2000e-02    kt1l=0.0000e+00 \
    ua1=0.0000e+00     ub1=0.0000e+00     uc1=0.0000e+00 \
    prt=0.0000e+00 \
   cgso=1.2000e-10    cgdo=1.2000e-10    cgbo=1.1000e-10 \
   cgdl=0.0000e+00    cgsl=0.0000e+00  ckappa=6.0000e-01 \
     cf=0.0000e+00     elm=5.0000e+00 \
  xpart=1.0000e+00     clc=1.0000e-15     cle=6.0000e-01 \
\
   rdsw=1.0920e+03 \
   cdsc=7.9440e-03   cdscb=0.0000e+00   cdscd=8.4480e-05 \
   prwb=0.0000e+00    prwg=0.0000e+00     cit=1.0000e-03 \
tox=7.7000e-09 \
  ngate=0.0000e+00 \
    nlx=1.1320e-07 \
     xl=0.0000e+00      xw=0.0000e+00 \
     af=1.3580e+00      kf=3.4460e-26      ef=1.0000e+00 \
   noia=1.7020e+20    noib=5.4630e+05    noic=-1.400e-11 \
     rd=0.0000e+00      rs=0.0000e+00     rsh=8.2000e+01 \
   minr=1.000e-03 \
    rdc=0.0000e+00     rsc=0.0000e+00 lint=6.0000e-07 \
wint=2.6050e-08   ldif=0.000e+00    hdif=6.0000e-07 \
     xj=3.0000e-07      js=5.1000e-07 \
      n=1.0000e+00 \
  dskip=no          tlev=0           tlevc=0         \
    jsw=6.0000e-13 \
     cj=8.0000e-05    cjsw=5.1000e-10 \
     fc=0.0000e+00    fcsw=0.000e+00 \
     mj=3.9000e-01    mjsw=2.7000e-01 \
     pb=5.3000e-01    pbsw=6.9000e-01     xti=2.0260e+00
ends modnh
// ----------------------------------------------------------------------
// Owner: austriamicrosystems
// HIT-Kit: Digital
// ************************ SIMULATION PARAMETERS ************************
//  ----------------------------------------------------------------------
//  format    : Spectre (Spectre Direct)
//  model     : MOS BSIM3v3
//  process   : c35
//  revision  : 4.0;
//  extracted : Wafer B26654W01 2005/10/05 REVISION 4.0; wpc(5481)
//  doc#      : Eng-182  REV 6.0
//  ----------------------------------------------------------------------
//                    TYPICAL MEAN WORST NOISE CONDITION
//  ----------------------------------------------------------------------
//  HV-TRANSISTOR
//  ----------------------------------------------------------------------
inline subckt modnhl ( d g s b )
// Parameters: w l nrd nrs ad as pd ps
parameters w=1.0e-6 l=1.0e-6 nrd=0.0 nrs=0.0 ad=0.0 as=0.0 pd=0.0 ps=0.0 mult=1
+ ws=w
+ ls=l
+ dvthmat=mv_modnhl*(0.67e-08/sqrt(ls*ws*mult)) dumat=mu_modnhl*(4.9e-9/sqrt(ls*ws*mult))
//
if (modnhl==1){
modnhl ( d1 g s b ) mosinsub w=ws l=ls nrd=0 nrs=8.0000e-07/ws ad=ad as=as pd=pd ps=ps
rd ( d1 d ) resistor r=(1.2030e+03*4.0000e-06/(ws+(0.0000e+00))) tc1=6.2000e-03
}else
modnhl ( d s ) resistor r=1e30
notvalid paramtest errorif=(modnhl==0) \
message="
***************************************************
*
* nmoshl is not valid in selected process option.
*
***************************************************"
//
model mosinsub bsim3v3 version=3.1 type=n  capmod=2.0000e+00 \
 mobmod=1.0000e+00  nqsmod=0.0000e+00  noimod=3 \
   vbox=1.000e+03      k1=5.0855e-01 \
     k2=-0.0000e+00      k3=0.0000e+00     k3b=0.0000e+00 \
    nch=1.5880e+17 vth0=3.6560e-01+dvthmat \
   voff=-5.119e-02    dvt0=0.0000e+00    dvt1=1.2960e+00 \
   dvt2=1.3110e-02    keta=-3.955e-02 \
 pscbe1=1.0000e+10  pscbe2=1.0240e-05 \
 alpha0=0.0000e+00   beta0=3.0000e+01 \
  dvt0w=0.0000e+00   dvt1w=0.0000e+00   dvt2w=0.0000e+00 \
     ua=1.0000e-30      ub=1.9490e-18      uc=1.2170e-10 \
u0=3.4270e+02+(3.4270e+02)*dumat \
   dsub=5.0000e-01    eta0=0.0000e+00    etab=0.0000e+00 \
nfactor=1.1530e+00 \
     em=4.1000e+07    pclm=2.9400e-01 \
  drout=5.0000e-01 \
     a0=3.3100e-01      a1=0.0000e+00      a2=1.0000e+00 \
   pvag=0.0000e+00    vsat=2.4020e+06     ags=3.2310e-01      b0=0.0000e+00      b1=0.0000e+00 \
  delta=3.1850e-02 pdiblcb=2.0670e-04 \
pdiblc1=3.0900e-02 pdiblc2=6.3750e-04 \
     w0=1.1450e-07 \
    dlc=0.0000e+00 \
    dwc=0.0000e+00     dwb=0.0000e+00     dwg=0.0000e+00 \
     ll=0.0000e+00      lw=0.0000e+00     lwl=0.0000e+00 \
    lln=1.0000e+00     lwn=1.0000e+00      wl=0.0000e+00 \
     ww=0.0000e+00     wwl=0.0000e+00     wln=1.0000e+00 \
    wwn=1.0000e+00 \
     at=3.3000e+04     ute=-1.700e+00 \
    kt1=-3.001e-01     kt2=2.2000e-02    kt1l=0.0000e+00 \
    ua1=0.0000e+00     ub1=0.0000e+00     uc1=0.0000e+00 \
    prt=0.0000e+00 \
   cgso=1.2000e-10    cgdo=1.2000e-10    cgbo=1.1000e-10 \
   cgdl=0.0000e+00    cgsl=0.0000e+00  ckappa=6.0000e-01 \
     cf=0.0000e+00     elm=5.0000e+00 \
  xpart=1.0000e+00     clc=1.0000e-15     cle=6.0000e-01 \
\
   rdsw=1.0920e+03 \
   cdsc=0.0000e+00   cdscb=0.0000e+00   cdscd=0.0000e+00 \
   prwb=0.0000e+00    prwg=0.0000e+00     cit=-2.050e-04 \
tox=7.6600e-09 \
  ngate=0.0000e+00 \
    nlx=1.1320e-07 \
     xl=0.0000e+00      xw=0.0000e+00 \
     af=1.4000e+00      kf=3.7700e-26      ef=1.0000e+00 \
   noia=1.5360e+20    noib=3.5840e+05    noic=-1.304e-11 \
     rd=0.0000e+00      rs=0.0000e+00     rsh=7.5000e+01 \
   minr=1.000e-03 \
    rdc=0.0000e+00     rsc=0.0000e+00 lint=6.0000e-07 \
wint=0.0000e+00   ldif=0.000e+00    hdif=8.0000e-07 \
     xj=3.0000e-07      js=5.1000e-07 \
      n=1.0000e+00 \
  dskip=no          tlev=0           tlevc=0         \
    jsw=6.0000e-13 \
     cj=8.3000e-04    cjsw=2.5000e-10 \
     fc=0.0000e+00    fcsw=0.000e+00 \
     mj=3.4000e-01    mjsw=2.3000e-01 \
     pb=6.9000e-01    pbsw=6.9000e-01     xti=2.0300e+00
ends modnhl
// ----------------------------------------------------------------------
// Owner: austriamicrosystems
// HIT-Kit: Digital
// ************************ SIMULATION PARAMETERS ************************
//  ----------------------------------------------------------------------
//  format    : Spectre (Spectre Direct)
//  model     : MOS BSIM3v3
//  process   : c35
//  revision  : ;
//  extracted : B58737.W09PE6; 2008-06; kmo(5966)
//  doc#      : ENG-327 Rev.2.0
//  ----------------------------------------------------------------------
//                         TYPICAL MEAN WORST NOISE CONDITION
//  ----------------------------------------------------------------------
//  HV-TRANSISTOR
//  ----------------------------------------------------------------------
inline subckt modn30m ( d g s b )
// Parameters: w l nrd nrs ad as pd ps
parameters w=1.0e-6 l=1.0e-6 nrd=0.0 nrs=0.0 ad=0.0 as=0.0 pd=0.0 ps=0.0 mult=1 gv=(7.6860e-08/l + 9.1600e-01) dcdc=1
+ dvthmat=mv_modn30m*(0.56e-08/sqrt(l*w*mult)) dumat=mu_modn30m*(2.9e-9/sqrt(l*w*mult))
if (modn30m==1){
//
modn30m ( d1 g s1 b ) mosinsub w=w l=l nrd=0 nrs=8.0000e-07/w ad=0 as=as pd=0 ps=ps
rd ( d1 d ) resistor r=(9.9260e-01/(w+(1.6670e-06))) tc1=6.0000e-03
xj1 ( d gj d1 ) modn30mjfet1 w=w
xj2 ( d gj d1 ) modn30mjfet2 w=w
e1 ( d1 gj d1 s ) vcvs gain=gv min=-25 max=25
cgdx ( g d ) capacitor c=(3.5750e-10*w)
v1 ( s1 s ) vsource dc=0 type=dc
i1 ( d b ) bsource i=((6.1450e-10)/(l+(0.0000e+00))+(6.1590e-03))*i("v1:p")*(max((v(d,g)+(1.8290e-02)),1e-15))**(4.1480e+00)*exp((-1.4550e+01)/max((v(d,g)+(1.8290e-02)),1e-10))*(w+0.0000e+00)/w/(1+2.8000e+04*exp(7.7390e-03*i("v1:p")/(w+0.0000e+00)))
xdw ( b d1 ) modn30mnwd area=(1e-06*2.35*(w+1e-06*16)) perimeter=(4e-06*2.35+(w+1e-06*16))
}else
modn30m ( d s ) resistor r=1e30
notvalid paramtest errorif=(modn30m==0) \
message="
***************************************************
*
* nmos30m is not valid in selected process option.
*
***************************************************"
//
model mosinsub bsim3v3 version=3.1 type=n  capmod=2.0000e+00 \
 mobmod=1.0000e+00  nqsmod=0.0000e+00  noimod=3.0000e+00 \
   vbox=1.000e+03      k1=9.3509e-01 \
     k2=6.1371e-02      k3=2.3030e-01     k3b=-1.516e-02 \
    nch=2.1340e+17 vth0=7.0770e-01+dvthmat \
   voff=-6.529e-02    dvt0=1.1390e-03    dvt1=1.0310e-01 \
   dvt2=-1.601e-01    keta=-1.236e-02 \
 pscbe1=3.5770e+12  pscbe2=5.7730e-12 \
 alpha0=0.0000e+00   beta0=3.0000e+01 \
  dvt0w=3.0490e-01   dvt1w=2.3530e+05   dvt2w=-2.685e+00 \
     ua=5.6220e-12      ub=9.5730e-19      uc=7.1200e-13 \
u0=4.4180e+02+(4.4180e+02)*dumat \
   dsub=5.2500e+00    eta0=1.0000e-07    etab=-3.000e-01 \
nfactor=9.0620e-01 \
     em=4.1000e+07    pclm=2.8550e+00 \
  drout=5.0000e-01 \
     a0=8.2080e-01      a1=0.0000e+00      a2=1.0000e+00 \
   pvag=0.0000e+00    vsat=8.9380e+04     ags=1.8620e-02      b0=3.0590e-09      b1=2.6720e-02 \
  delta=3.7770e-05 pdiblcb=1.0000e-12 \
pdiblc1=5.1750e-04 pdiblc2=3.7770e-07 \
     w0=-4.630e-06 \
    dlc=-5.451e-07 \
    dwc=2.7390e-07     dwb=0.0000e+00     dwg=0.0000e+00 \
     ll=0.0000e+00      lw=0.0000e+00     lwl=0.0000e+00 \
    lln=1.0000e+00     lwn=1.0000e+00      wl=0.0000e+00 \
     ww=0.0000e+00     wwl=0.0000e+00     wln=1.0000e+00 \
    wwn=1.0000e+00 \
     at=3.3000e+04     ute=-1.710e+00 \
    kt1=-4.600e-01     kt2=2.2000e-02    kt1l=0.0000e+00 \
    ua1=0.0000e+00     ub1=0.0000e+00     uc1=0.0000e+00 \
    prt=0.0000e+00 \
   cgso=1.0710e-10    cgdo=1.0000e-15    cgbo=1.1000e-10 \
   cgdl=5.0000e-10    cgsl=4.8800e-10  ckappa=1.9890e+00 \
     cf=0.0000e+00     elm=5.0000e+00 \
  xpart=5.0000e-01     clc=1.0000e-15     cle=6.0000e-01 \
\
   rdsw=0.0000e+00 \
   cdsc=1.9360e-06   cdscb=1.0000e-12   cdscd=1.0740e-08 \
   prwb=0.0000e+00    prwg=0.0000e+00     cit=1.0740e-06 \
tox=1.5400e-08 \
  ngate=0.0000e+00 \
    nlx=2.6040e-07 \
     xl=0.0000e+00      xw=0.0000e+00 \
     af=1.9886e+00      kf=1.6086e-24      ef=1.0000e+00 \
   noia=2.5794e+19    noib=1.0199e+05    noic=-2.372e-12 \
     rd=0.0000e+00      rs=0.0000e+00     rsh=7.5000e+01 \
   minr=1.000e-03 \
    rdc=0.0000e+00     rsc=0.0000e+00 lint=-2.271e-07 \
wint=2.7390e-07   ldif=0.000e+00    hdif=8.0000e-07 \
     xj=9.0000e-07      js=3.5530e-07 \
      n=1.0000e+00 \
  dskip=no          tlev=0           tlevc=0         \
    jsw=1.7560e-12 \
     cj=8.4000e-04    cjsw=2.5000e-10 \
     fc=0.0000e+00    fcsw=0.000e+00 \
     mj=3.4000e-01    mjsw=2.3000e-01 \
     pb=6.9000e-01    pbsw=6.9000e-01     xti=2.0260e+00
ends modn30m
// HV-jfet 1
inline subckt modn30mjfet1 (d b s)
parameters w=1e-6
modn30mjfet1 (d b s) rnjfetinsub
model rnjfetinsub jfet type=n \
beta=4.4210e+00/(1+(2.8000e-03)*(temp-(2.7000e+01)))*(w+(1.6670e-06))/(1+(6.0000e-03)*(temp-27)) \
vto=-5.700e+00*(1+(2.8000e-03)*(temp-(2.7000e+01))) \
lambda=0.0000e+00 \
is=0.0000e+00  pb=5.0000e-01 \
cgs=0.0000e+00 rs=0.0000e+00 \
cgd=0.0000e+00 rd=0.0000e+00
ends modn30mjfet1
// HV-jfet 2
inline subckt  modn30mjfet2 (d b s)
parameters w=1e-6
modn30mjfet2 (d b s) rnjfetinsub
model rnjfetinsub jfet type=n \
beta=4.4900e+00/(1+(2.8000e-03)*(temp-(2.7000e+01)))*(w+(1.6670e-06))/(1+(6.0000e-03)*(temp-27)) \
vto=-7.957e+00*(1+(2.8000e-03)*(temp-(2.7000e+01))) \
lambda=0.0000e+00 \
is=0.0000e+00  pb=5.0000e-01 \
cgs=0.0000e+00 rs=0.0000e+00 \
cgd=0.0000e+00 rd=0.0000e+00
ends modn30mjfet2
//

inline subckt modn30mnwd ( a c )
parameters area=1.0e-12 perimeter=1.0e-6
modn30mnwd ( a c ) diodeinsub area=area perim=perimeter region=off
model diodeinsub diode level=1 dskip=no \
is=1.676e-06          isw=2.158e-11                n=1.000e+00 ns=1.000e+00 \
minr=0.100e+00   imax=(1.000e+00/area) \
cj0=8.798e-05        m=2.737e-01                  vj=5.300e-01 tt=0.000e+00 \
cjsw=6.611e-10       mjsw=2.122e-01             vjsw=5.300e-01 fc=0.000e+00\
af=1.000e+00     kf=0.000e+00            xti=1.366e+00
ends modn30mnwd
// ----------------------------------------------------------------------
// Owner: austriamicrosystems
// HIT-Kit: Digital
// ************************ SIMULATION PARAMETERS ************************
//  ----------------------------------------------------------------------
//  format    : Spectre (Spectre Direct)
//  model     : MOS BSIM3v3
//  process   : c35
//  revision  : ;
//  extracted : B58737.W09PE6; 2008-06; kmo(5966)
//  doc#      : ENG-327 Rev.2.0
//  ----------------------------------------------------------------------
//                         TYPICAL MEAN WORST NOISE CONDITION
//  ----------------------------------------------------------------------
//  HV-TRANSISTOR
//  ----------------------------------------------------------------------
inline subckt modn18t ( d g s b )
// Parameters: w l nrd nrs ad as pd ps
parameters w=1.0e-6 l=1.0e-6 nrd=0.0 nrs=0.0 ad=0.0 as=0.0 pd=0.0 ps=0.0 mult=1 gv=(2.8290e-07/l + 8.9230e-01) dcdc=1
+ dvthmat=mv_modn18t*(0.78e-08/sqrt(l*w*mult)) dumat=mu_modn18t*(6.9e-09/sqrt(l*w*mult))
if (modn18t==1){
//
modn18t ( d1 g s1 b ) mosinsub w=w l=l nrd=0 nrs=8.0000e-07/w ad=0 as=as pd=0 ps=ps
rd ( d1 d ) resistor r=(9.9540e-01/(w+(2.4730e-06))) tc1=5.0000e-03
xj1 ( d gj d1 ) modn18tjfet1 w=w
xj2 ( d gj d1 ) modn18tjfet2 w=w
e1 ( d1 gj d1 s ) vcvs gain=gv min=-25 max=25
cgdx ( g d ) capacitor c=(4.4000e-10*w)
v1 ( s1 s ) vsource dc=0 type=dc
i1 ( d b ) bsource i=((5.3850e-10)/(l+(0.0000e+00))+(4.8260e-03))*i("v1:p")*(max((v(d,g)+(2.9600e-02)),1e-15))**(3.8580e+00)*exp((-4.2900e+00)/max((v(d,g)+(2.9600e-02)),1e-10))*(w+0.0000e+00)/w/(1+3.3810e+04*exp(5.3330e-03*i("v1:p")/(w+0.0000e+00)))
xdw ( b d1 ) modn18tnwd area=(1e-06*2.35*(w+1e-06*16)) perimeter=(4e-06*2.35+(w+1e-06*16))
}else
modn18t ( d s ) resistor r=1e30
notvalid paramtest errorif=(modn18t==0) \
message="
***************************************************
*
* nmos18t is not valid in selected process option.
*
***************************************************"
//
model mosinsub bsim3v3 version=3.1 type=n  capmod=2.0000e+00 \
 mobmod=1.0000e+00  nqsmod=0.0000e+00  noimod=3.0000e+00 \
   vbox=1.000e+03      k1=6.0871e-01 \
     k2=-3.258e-03      k3=-2.570e+00     k3b=1.9850e+00 \
    nch=2.2110e+17 vth0=4.6760e-01+dvthmat \
   voff=-8.829e-02    dvt0=1.8190e-01    dvt1=1.0200e-01 \
   dvt2=-5.409e-02    keta=-3.582e-02 \
 pscbe1=3.5770e+12  pscbe2=5.7730e-12 \
 alpha0=0.0000e+00   beta0=3.0000e+01 \
  dvt0w=7.9230e-01   dvt1w=6.0330e+05   dvt2w=-2.792e+00 \
     ua=2.1750e-10      ub=4.8850e-19      uc=1.2070e-10 \
u0=3.8760e+02+(3.8760e+02)*dumat \
   dsub=5.2500e+00    eta0=1.0000e-07    etab=-3.000e-01 \
nfactor=8.6770e-01 \
     em=4.1000e+07    pclm=6.0510e+00 \
  drout=5.0000e-01 \
     a0=7.6440e-01      a1=0.0000e+00      a2=1.0000e+00 \
   pvag=0.0000e+00    vsat=5.5760e+04     ags=2.3440e-01      b0=4.4050e-09      b1=2.6720e-02 \
  delta=2.5490e-05 pdiblcb=1.0000e-12 \
pdiblc1=2.2650e+00 pdiblc2=1.0000e-09 \
     w0=-7.990e-01 \
    dlc=-7.640e-07 \
    dwc=1.6680e-07     dwb=0.0000e+00     dwg=0.0000e+00 \
     ll=0.0000e+00      lw=0.0000e+00     lwl=0.0000e+00 \
    lln=1.0000e+00     lwn=1.0000e+00      wl=0.0000e+00 \
     ww=0.0000e+00     wwl=0.0000e+00     wln=1.0000e+00 \
    wwn=1.0000e+00 \
     at=3.3000e+04     ute=-1.720e+00 \
    kt1=-3.210e-01     kt2=2.2000e-02    kt1l=0.0000e+00 \
    ua1=0.0000e+00     ub1=0.0000e+00     uc1=0.0000e+00 \
    prt=0.0000e+00 \
   cgso=1.1750e-10    cgdo=1.0000e-15    cgbo=1.1000e-10 \
   cgdl=4.4020e-10    cgsl=5.0000e-10  ckappa=6.2280e-01 \
     cf=0.0000e+00     elm=5.0000e+00 \
  xpart=5.0000e-01     clc=1.0000e-15     cle=6.0000e-01 \
\
   rdsw=0.0000e+00 \
   cdsc=5.0330e-20   cdscb=2.9060e-04   cdscd=7.3780e-10 \
   prwb=0.0000e+00    prwg=0.0000e+00     cit=7.3780e-08 \
tox=7.6000e-09 \
  ngate=0.0000e+00 \
    nlx=1.4630e-07 \
     xl=0.0000e+00      xw=0.0000e+00 \
     af=2.0045e+00      kf=8.5977e-25      ef=1.0000e+00 \
   noia=4.8618e+18    noib=2.9560e+04    noic=-2.148e-13 \
     rd=0.0000e+00      rs=0.0000e+00     rsh=7.5000e+01 \
   minr=1.000e-03 \
    rdc=0.0000e+00     rsc=0.0000e+00 lint=-3.414e-07 \
wint=1.6680e-07   ldif=0.000e+00    hdif=8.0000e-07 \
     xj=9.0000e-07      js=3.5530e-07 \
      n=1.0000e+00 \
  dskip=no          tlev=0           tlevc=0         \
    jsw=1.7560e-12 \
     cj=8.4000e-04    cjsw=2.5000e-10 \
     fc=0.0000e+00    fcsw=0.000e+00 \
     mj=3.4000e-01    mjsw=2.3000e-01 \
     pb=6.9000e-01    pbsw=6.9000e-01     xti=2.0260e+00
ends modn18t
// HV-jfet 1
inline subckt modn18tjfet1 (d b s)
parameters w=1e-6
modn18tjfet1 (d b s) rnjfetinsub
model rnjfetinsub jfet type=n \
beta=4.0710e+00/(1+(1.6000e-03)*(temp-(2.7000e+01)))*(w+(2.4730e-06))/(1+(5.0000e-03)*(temp-27)) \
vto=-7.402e+00*(1+(1.6000e-03)*(temp-(2.7000e+01))) \
lambda=0.0000e+00 \
is=0.0000e+00  pb=5.0000e-01 \
cgs=0.0000e+00 rs=0.0000e+00 \
cgd=0.0000e+00 rd=0.0000e+00
ends modn18tjfet1
// HV-jfet 2
inline subckt  modn18tjfet2 (d b s)
parameters w=1e-6
modn18tjfet2 (d b s) rnjfetinsub
model rnjfetinsub jfet type=n \
beta=1.9980e+00/(1+(1.6000e-03)*(temp-(2.7000e+01)))*(w+(2.4730e-06))/(1+(5.0000e-03)*(temp-27)) \
vto=-7.947e+00*(1+(1.6000e-03)*(temp-(2.7000e+01))) \
lambda=0.0000e+00 \
is=0.0000e+00  pb=5.0000e-01 \
cgs=0.0000e+00 rs=0.0000e+00 \
cgd=0.0000e+00 rd=0.0000e+00
ends modn18tjfet2
//

inline subckt modn18tnwd ( a c )
parameters area=1.0e-12 perimeter=1.0e-6
modn18tnwd ( a c ) diodeinsub area=area perim=perimeter region=off
model diodeinsub diode level=1 dskip=no \
is=2.159e-06          isw=3.227e-11                n=1.000e+00 ns=1.000e+00 \
minr=0.100e+00   imax=(1.000e+00/area) \
cj0=8.992e-05        m=2.671e-01                  vj=5.300e-01 tt=0.000e+00 \
cjsw=6.406e-10       mjsw=2.161e-01             vjsw=5.300e-01 fc=0.000e+00\
af=1.000e+00     kf=0.000e+00            xti=4.786e-01
ends modn18tnwd

// ----------------------------------------------------------------------
// Owner: austriamicrosystems
// HIT-Kit: Digital
// ************************ SIMULATION PARAMETERS ************************
//  ----------------------------------------------------------------------
//  format    : Spectre (Spectre Direct)
//  model     : MOS HiSIM_HV
//  process   : c35
//  revision  : REVISION 3.0 Wafer C50118W01 2013/12/12;
//  extracted : MCT;
//  doc#      : Eng-327 REV 5.0
//  ----------------------------------------------------------------------
//                      TYPICAL MEAN WORST NOISE CONDITION
//  ----------------------------------------------------------------------
//
// UNSYMMETRIC HV-TRANSISTOR WITH EXTENDED PARASITICS
// PARAMS: NRD NRS AD AS PD PS AW PW (SEE NETLIST FORMAT DOC.)
// NMOS: N-Well Diode
// PMOS: P-Well Diode + PSUB+Diode
//  ----------------------------------------------------------------------
inline subckt modpd30m ( d g s b psub )
// Parameters: w l nrd nrs ad as pd ps
parameters w=1.0e-6 l=1.0e-6 nrd=0.0 nrs=0.0 ad=0.0 as=0.0 pd=0.0 ps=0.0 mult=1 dtemp=0
+ isoVoltage=50
+ dvthmat=(mv_modpd30m)*(1.73e-08/sqrt(l*w*mult)) dumat=(mu_modpd30m)*(6.15e-09/sqrt(l*w*mult))
if (modpd30m==1){
modpd30m ( d g s b ) mosinsub w=w l=l nrd=0 nrs=8.0000e-07/w ad=0 as=as pd=0 ps=ps
xpd ( d b ) modpd30mpd area=w*3.7e-06 perimeter=3.7e-06*2*mult
xnwd ( psub b ) modpd30mnwd area=(w+1e-06*23.6)*(l+1e-06*8.25) perimeter=4*(l+1e-06*8.25)+(w+1e-06*23.6)
}else
modpd30m ( d s ) resistor r=1e30
notvalid paramtest errorif=(modpd30m==0) \
message="
***************************************************
*
* pmosd30m is not valid in selected process option.
*
***************************************************"
//
model mosinsub hisim_hv version=1.230e+00 type=p \
 corsrd=3.0000e+00  coovlp=1.0000e+00 coovlps=1.0000e+00 \
 coisub=0.0000e+00  coiigs=0.0000e+00  cogidl=0.0000e+00 \
 coisti=0.0000e+00  coadov=1.0000e+00   conqs=0.0000e+00 \
   corg=0.0000e+00 corbnet=0.0000e+00 coflick=1.0000e+00 \
cothrml=1.0000e+00   coign=0.0000e+00  coiprv=1 \
  codfm=0.0000e+00 coselfheat=1.0000e+00   cosym=0.0000e+00  \
cosubnode=0.0000e+00  cotemp=0.0000e+00 coldrift=1.0000e+00 \
coqovsm=1.0000e+00  shemax=5.0000e+02  copprv=1.0000e+00
***************************************************************************
*                             Extension to LDMOS                          *
***************************************************************************
+loverld=2.0370e-07   lover=4.9860e-08 ldrift1=1.0000e-06 \
ldrift2=1.0000e-06  novers=1.8290e+17   nover=2.0600e+17
***************************************************************************
*                                   Charges                               *
***************************************************************************
+     xl=0.0000e+00      xw=5.3321e-11     xld=0.0000e+00 \
  xldld=-3.000e-07     xwd=1.6634e-06    xwdc=0.0000e+00   xwdld=0.0000e+00 \
     ll=0.0000e+00     lld=0.0000e+00     lln=0.0000e+00      wl=0.0000e+00 \
    wld=0.0000e+00     wln=0.0000e+00      vfbc=-4.508e-01 \
    vbi=1.1000e+00      tox=1.5000e-08    ddltmax=2.4843e+00 \
ddltslp=0.0000e+00 ddltict=1.0000e+01   kappa=3.9000e+00
***************************************************************************
*                          Threshold Voltage Shift                        *
***************************************************************************
+  parl2=1.0000e-08      sc1=1.2113e+01     sc2=5.0000e-02 \
    sc3=0.0000e+00     sc4=0.0000e+00  pthrou=0.0000e+00 \
     nsubp=1.2013e+17      lp=1.3447e-07     bs1=0.0000e+00 \
    bs2=9.0000e-01    scp1=1.5395e+00    scp2=1.0000e-01 \
   scp3=0.0000e+00   scp21=0.0000e+00   scp22=0.0000e+00 \
  npext=1.0000e+17   lpext=1.0000e-50
***************************************************************************
*                   Depletion Effect of the Gate Poly-Si                  *
***************************************************************************
+   pgd1=0.0000e+00    pgd2=1.0000e+00    pgd3=8.0000e-01 \
   pgd4=0.0000e+00
***************************************************************************
*                       Quantum Mechanical Effects                        *
***************************************************************************
+   qme1=0.0000e+00    qme2=1.0000e+00    qme3=0.0000e+00
***************************************************************************
*                            Mobility Model                               *
***************************************************************************
+muecb0=1.0000e+02     muecb1=7.5427e+01 mueph0=3.0000e-01 \
mueph1=8.3713e+03 muephl=4.3271e-01  mueplp=1.0000e+00 \
 muesr0=2.2790e+00      muesr1=8.6146e+15 muesrl=-1.087e-01 \
 mueslp=1.0000e+00    ndep=1.0000e+00   ndepl=0.0000e+00 \
 ndeplp=1.0000e+00    ninv=5.0000e-01   ninvd=0.0000e+00 \
     bb=1.0000e+00     vmax=6.4148e+06 \
  vover=3.2667e+00 \
 voverp=2.0000e+00
***************************************************************************
*                        Channel Length Modulation                        *
***************************************************************************
+   clm1=5.0000e-01    clm2=4.0000e+00    clm3=1.0000e+00 \
   clm5=1.0000e+00    clm6=0.0000e+00
***************************************************************************
*                          Narrow Channel Effects                         *
***************************************************************************
+    wfc=0.0000e+00   wvth0=-2.159e-01     nsubc=5.5601e+16 \
 nsubcw=0.0000e+00 nsubcwp=1.0000e+00  nsubp0=0.0000e+00 \
 nsubwp=1.0000e+00  muephw=4.5673e+00  muepwp=1.0000e+00 \
 muesrw=7.8626e-02  mueswp=1.0000e+00  vthsti=0.0000e+00 \
  vdsti=0.0000e+00  scsti1=0.0000e+00  scsti2=0.0000e+00 \
   nsti=1.0000e+17    wsti=0.0000e+00   wstil=0.0000e+00 \
 wstilp=1.0000e+00   wstiw=0.0000e+00  wstiwp=1.0000e+00 \
    wl1=0.0000e+00    wl1p=1.0000e+00     wl2=-1.938e-01 \
   wl2p=1.0000e+00  muephs=-5.777e-01  muepsp=1.0000e+00 \
 vovers=-1.000e-01 voversp=0.0000e+00
***************************************************************************
*                          Source/Drain Diffusion                         *
***************************************************************************
+nsubpsti1=0.0000e+00 nsubpsti2=0.0000e+00 nsubpsti3=1.0000e+00 \
muesti1=0.0000e+00 muesti2=0.0000e+00 muesti3=1.0000e+00 \
  saref=1.0000e-06   sbref=1.0000e-06
***************************************************************************
*                         Temperature Dependencies                        *
***************************************************************************
+    eg0=1.1790e+00  bgtmp1=9.0255e-05  bgtmp2=-2.432e-07 \
 muetmp=1.2226e+00    tnom=2.7000e+01    vtmp=3.6866e-01 \
   egig=0.0000e+00 igtemp2=0.0000e+00 igtemp3=0.0000e+00 \
rdtemp1=3.4836e-04 rdtemp2=2.6548e-06 rdvdtemp1=-5.189e-04 \
rdvdtemp2=9.7855e-07
***************************************************************************
*                                Resistances                              *
***************************************************************************
    +rd=7.8094e-03      rs=0.0000e+00     rsh=0.0000e+00 \
   rshg=0.0000e+00    rbpb=5.0000e+01    rbpd=5.0000e+01 \
   rbps=5.0000e+01 \
 rdvg11=6.4018e+00  rdvg12=1.6108e+01     rdvd=4.0529e-02 \
   rdvb=7.4912e-02     rds=-7.748e-01    rdsp=1.0000e+00 \
  rdvdl=0.0000e+00   rdvds=-4.921e-01  rdvdsp=1.0000e+00 \
 rdov11=0.0000e+00  rdov12=1.0000e+00  rdov13=1.0000e+00 \
 rdslp1=0.0000e+00    rd20=0.0000e+00    rd21=1.0000e+00 \
   rd22=-1.312e-01   rd22d=0.0000e+00     rd23=3.7023e-01 \
  rd23l=5.6859e-01  rd23lp=1.0000e+00   rd23s=-1.675e+00 \
 rd23sp=1.0000e+00    rd24=0.0000e+00    rd25=0.0000e+00 \
  gbmin=1.0000e-12
***************************************************************************
*                                Capacitances                             *
***************************************************************************
+    xqy=0.0000e+00    xqy1=0.0000e+00    xqy2=2.0000e+00 \
vfbover=-1.000e+00   qovsm=2.0000e-01   ovslp=2.0000e-08 \
  ovmag=5.0000e+02    cgso=2.0870e-10    cgdo=3.8610e-10 \
   cgbo=1.1000e-10   tpoly=2.0000e-07
***************************************************************************
*                              Leakage Currents                           *
***************************************************************************
+   sub1=5.0000e-02   sub1l=2.5000e-03  sub1lp=1.0000e+00 \
   sub2=3.0048e+01   sub2l=2.0000e-06    svds=8.0000e-01 \
    slg=3.0000e-08    slgl=0.0000e+00   slglp=1.0000e+00 \
   svbs=5.0000e-01   svbsl=0.0000e+00  svbslp=1.0000e+00 \
   svgs=8.0000e-01   svgsl=0.0000e+00  svgslp=1.0000e+00 \
  svgsw=0.0000e+00  svgswp=1.0000e+00   ibpc1=0.0000e+00 \
  ibpc2=0.0000e+00  subld1=0.0000e+00  subld2=0.0000e+00 \
 gleak1=5.0000e+01  gleak2=1.0000e+07  gleak3=6.0000e-02 \
 gleak4=4.0000e+00  gleak5=7.5000e+03  gleak6=2.5000e-01 \
 gleak7=1.0000e-06   glkb1=5.0000e-16   glkb2=1.0000e+00 \
  glkb3=0.0000e+00  glksd1=1.0000e-15  glksd2=1.0000e-02 \
 glksd3=-1.000e-02 glpart1=5.0000e-01     fn1=0.0000e+00 \
    fn2=0.0000e+00     fn3=0.0000e+00    fvbs=0.0000e+00 \
  gidl1=2.0000e+00   gidl2=3.0000e+07   gidl3=9.0000e-01 \
  gidl4=9.0000e-01   gidl5=2.0000e-01
***************************************************************************
*                             S/B and D/B Diodes                          *
***************************************************************************
+    js0=3.0890e-07   js0sw=1.1310e-13      nj=1.0000e+00 \
   njsw=1.0000e+00     xti=3.8400e+00    xti2=3.8400e+00 \
   divx=0.0000e+00    cisb=0.0000e+00     cvb=0.0000e+00 \
  ctemp=0.0000e+00   cisbk=0.0000e+00    cvbk=0.0000e+00 \
     cj=1.3600e-03    cjsw=3.5000e-10   cjswg=3.5000e-10 \
     mj=5.4000e-01    mjsw=4.6000e-01   mjswg=4.6000e-01 \
     pb=1.0200e+00    pbsw=1.0200e+00   pbswg=1.0200e+00 \
 vdiffj=6.0000e-04
***************************************************************************
*                                   Noise                                 *
***************************************************************************
+  nftrp=3.2435e+07   nfalp=1.5485e-18     cit=0.0000e+00 \
  falph=1.0000e+00
***************************************************************************
*                           Non Quasi Static Model                        *
***************************************************************************
+   dly1=1.0000e-10    dly2=7.0000e-01    dly3=8.0000e-07 \
  dlyov=0.0000e+00
***************************************************************************
*                            Self heating Effect                          *
***************************************************************************
+   rth0=5.5684e-01    cth0=1.0000e-07   rth0w=-8.500e+00 \
 rth0wp=1.0000e+00  rth0nf=0.0000e+00
***************************************************************************
*                                   DFM                                   *
***************************************************************************
+ mphdfm=-3.000e-01
***************************************************************************
*                         Additional Node                                 *
***************************************************************************
+ pzadd0=5.0000e-03  vzadd0=1.0000e-02 \
 rdict1=1.0000e+00  rdict2=0.0000e+00  rdvdlp=1.0000e+00 \
 vbsmin=-1.050e+01  rdslp2=1.0000e+00
***************************************************************************
*                         Additional Node                                 *
***************************************************************************
+ rdvsub=3.0000e-01 rdvdsub=1.0000e+00  ddrift=1.0000e-06 \
 vbisub=7.0000e-01 nsubsub=1.0000e+15
ends modpd30m
//

inline subckt modpd30mpd ( a c )
parameters area=1.0e-12 perimeter=1.0e-6
modpd30mpd ( a c ) diodeinsub area=area perim=perimeter region=off
model diodeinsub diode level=1 dskip=no \
  is=6.1140e-07          isw=2.4910e-13 \
   n=1.0400e+00           ns=1.0400e+00 \
minr=0.100e+00          imax=(1.000e+00/area) \
 cj0=1.2340e-03           m=6.2660e-01 \
  vj=1.0200e+00           tt=0.000e+00 \
cjsw=2.8230e-10         mjsw=4.8760e-01 \
vjsw=1.0200e+00           fc=0.000e+00 \
  af=1.000e+00             kf=0.000e+00 \
 xti=2.7630e+00
ends modpd30mpd
//

inline subckt modpd30mnwd ( a c )
parameters area=1.0e-12 perimeter=1.0e-6
modpd30mnwd ( a c ) diodeinsub area=area perim=perimeter region=off
model diodeinsub diode level=1 dskip=no \
  is=7.101e-06          isw=5.386e-12 \
   n=1.000e+00      ns=1.000e+00 \
minr=0.100e+00    imax=(1.000e+00/area) \
 cj0=3.850e-04           m=2.982e-01 \
  vj=5.300e-01          vjsw=5.300e-01 \
  fc=0.000e+00        tt=0.000e+00 \
cjsw=0.000e+00       mjsw=4.401e-01 \
  af=1.000e+00     kf=0.000e+00 \
 xti=-3.138e+00
ends modpd30mnwd

// ----------------------------------------------------------------------
// Owner: austriamicrosystems
// HIT-Kit: Digital
// ************************ SIMULATION PARAMETERS ************************
//  ----------------------------------------------------------------------
//  format    : Spectre (Spectre Direct)
//  model     : MOS HiSIM_HV
//  process   : c35
//  revision  : REVISION 1.0 Wafer C50118W01 2013/12/12;
//  extracted : MCT;
//  doc#      : Eng-327 REV 5.0
//  ----------------------------------------------------------------------
//                      TYPICAL MEAN WORST NOISE CONDITION
//  ----------------------------------------------------------------------
//
// UNSYMMETRIC HV-TRANSISTOR WITH EXTENDED PARASITICS
// PARAMS: NRD NRS AD AS PD PS AW PW (SEE NETLIST FORMAT DOC.)
// NMOS: N-Well Diode
// PMOS: P-Well Diode + PSUB+Diode
//  ----------------------------------------------------------------------
inline subckt modp30m ( d g s b psub )
// Parameters: w l nrd nrs ad as pd ps
parameters w=1.0e-6 l=1.0e-6 nrd=0.0 nrs=0.0 ad=0.0 as=0.0 pd=0.0 ps=0.0 mult=1 dtemp=0
+ isoVoltage=50
+ dvthmat=(mv_modp30m)*(1.73e-08/sqrt(l*w*mult)) dumat=(mu_modp30m)*(6.15e-09/sqrt(l*w*mult))
if (modp30m==1){
modp30m ( d g s b ) mosinsub w=w l=l nrd=0 nrs=8.0000e-07/w ad=0 as=as pd=0 ps=ps
xpd ( d b ) modp30mpd area=w*3.7e-06 perimeter=3.7e-06*2*mult
xnwd ( psub b ) modp30mnwd area=(w+1e-06*23.6)*(l+1e-06*8.25) perimeter=4*(l+1e-06*8.25)+(w+1e-06*23.6)
}else
modp30m ( d s ) resistor r=1e30
notvalid paramtest errorif=(modp30m==0) \
message="
***************************************************
*
* pmosd30m is not valid in selected process option.
*
***************************************************"
//
model mosinsub hisim_hv version=1.230e+00 type=p \
 corsrd=3.0000e+00  coovlp=1.0000e+00 coovlps=1.0000e+00 \
 coisub=0.0000e+00  coiigs=0.0000e+00  cogidl=0.0000e+00 \
 coisti=0.0000e+00  coadov=1.0000e+00   conqs=0.0000e+00 \
   corg=0.0000e+00 corbnet=0.0000e+00 coflick=1.0000e+00 \
cothrml=1.0000e+00   coign=0.0000e+00  coiprv=1 \
  codfm=0.0000e+00 coselfheat=1.0000e+00   cosym=0.0000e+00  \
cosubnode=0.0000e+00  cotemp=0.0000e+00 coldrift=1.0000e+00 \
coqovsm=1.0000e+00  shemax=5.0000e+02  copprv=1.0000e+00
***************************************************************************
*                             Extension to LDMOS                          *
***************************************************************************
+loverld=2.0370e-07   lover=4.9860e-08 ldrift1=1.0000e-06 \
ldrift2=1.0000e-06  novers=1.8290e+17   nover=2.0600e+17
***************************************************************************
*                                   Charges                               *
***************************************************************************
+     xl=0.0000e+00      xw=5.3321e-11     xld=0.0000e+00 \
  xldld=-3.000e-07     xwd=1.6634e-06    xwdc=0.0000e+00   xwdld=0.0000e+00 \
     ll=0.0000e+00     lld=0.0000e+00     lln=0.0000e+00      wl=0.0000e+00 \
    wld=0.0000e+00     wln=0.0000e+00      vfbc=-4.508e-01 \
    vbi=1.1000e+00      tox=1.5000e-08    ddltmax=2.4843e+00 \
ddltslp=0.0000e+00 ddltict=1.0000e+01   kappa=3.9000e+00
***************************************************************************
*                          Threshold Voltage Shift                        *
***************************************************************************
+  parl2=1.0000e-08      sc1=1.2113e+01     sc2=5.0000e-02 \
    sc3=0.0000e+00     sc4=0.0000e+00  pthrou=0.0000e+00 \
     nsubp=1.2013e+17      lp=1.3447e-07     bs1=0.0000e+00 \
    bs2=9.0000e-01    scp1=1.5395e+00    scp2=1.0000e-01 \
   scp3=0.0000e+00   scp21=0.0000e+00   scp22=0.0000e+00 \
  npext=1.0000e+17   lpext=1.0000e-50
***************************************************************************
*                   Depletion Effect of the Gate Poly-Si                  *
***************************************************************************
+   pgd1=0.0000e+00    pgd2=1.0000e+00    pgd3=8.0000e-01 \
   pgd4=0.0000e+00
***************************************************************************
*                       Quantum Mechanical Effects                        *
***************************************************************************
+   qme1=0.0000e+00    qme2=1.0000e+00    qme3=0.0000e+00
***************************************************************************
*                            Mobility Model                               *
***************************************************************************
+muecb0=1.0000e+02     muecb1=7.5427e+01 mueph0=3.0000e-01 \
mueph1=8.3713e+03 muephl=4.3271e-01  mueplp=1.0000e+00 \
 muesr0=2.2790e+00      muesr1=8.6146e+15 muesrl=-1.087e-01 \
 mueslp=1.0000e+00    ndep=1.0000e+00   ndepl=0.0000e+00 \
 ndeplp=1.0000e+00    ninv=5.0000e-01   ninvd=0.0000e+00 \
     bb=1.0000e+00     vmax=6.4148e+06 \
  vover=3.2667e+00 \
 voverp=2.0000e+00
***************************************************************************
*                        Channel Length Modulation                        *
***************************************************************************
+   clm1=5.0000e-01    clm2=4.0000e+00    clm3=1.0000e+00 \
   clm5=1.0000e+00    clm6=0.0000e+00
***************************************************************************
*                          Narrow Channel Effects                         *
***************************************************************************
+    wfc=0.0000e+00   wvth0=-2.159e-01     nsubc=5.5601e+16 \
 nsubcw=0.0000e+00 nsubcwp=1.0000e+00  nsubp0=0.0000e+00 \
 nsubwp=1.0000e+00  muephw=4.5673e+00  muepwp=1.0000e+00 \
 muesrw=7.8626e-02  mueswp=1.0000e+00  vthsti=0.0000e+00 \
  vdsti=0.0000e+00  scsti1=0.0000e+00  scsti2=0.0000e+00 \
   nsti=1.0000e+17    wsti=0.0000e+00   wstil=0.0000e+00 \
 wstilp=1.0000e+00   wstiw=0.0000e+00  wstiwp=1.0000e+00 \
    wl1=0.0000e+00    wl1p=1.0000e+00     wl2=-1.938e-01 \
   wl2p=1.0000e+00  muephs=-5.777e-01  muepsp=1.0000e+00 \
 vovers=-1.000e-01 voversp=0.0000e+00
***************************************************************************
*                          Source/Drain Diffusion                         *
***************************************************************************
+nsubpsti1=0.0000e+00 nsubpsti2=0.0000e+00 nsubpsti3=1.0000e+00 \
muesti1=0.0000e+00 muesti2=0.0000e+00 muesti3=1.0000e+00 \
  saref=1.0000e-06   sbref=1.0000e-06
***************************************************************************
*                         Temperature Dependencies                        *
***************************************************************************
+    eg0=1.1790e+00  bgtmp1=9.0255e-05  bgtmp2=-2.432e-07 \
 muetmp=1.2226e+00    tnom=2.7000e+01    vtmp=3.6866e-01 \
   egig=0.0000e+00 igtemp2=0.0000e+00 igtemp3=0.0000e+00 \
rdtemp1=3.4836e-04 rdtemp2=2.6548e-06 rdvdtemp1=-5.189e-04 \
rdvdtemp2=9.7855e-07
***************************************************************************
*                                Resistances                              *
***************************************************************************
    +rd=7.8094e-03      rs=0.0000e+00     rsh=0.0000e+00 \
   rshg=0.0000e+00    rbpb=5.0000e+01    rbpd=5.0000e+01 \
   rbps=5.0000e+01 \
 rdvg11=6.4018e+00  rdvg12=1.6108e+01     rdvd=4.0529e-02 \
   rdvb=7.4912e-02     rds=-7.748e-01    rdsp=1.0000e+00 \
  rdvdl=0.0000e+00   rdvds=-4.921e-01  rdvdsp=1.0000e+00 \
 rdov11=0.0000e+00  rdov12=1.0000e+00  rdov13=1.0000e+00 \
 rdslp1=0.0000e+00    rd20=0.0000e+00    rd21=1.0000e+00 \
   rd22=-1.312e-01   rd22d=0.0000e+00     rd23=3.7023e-01 \
  rd23l=5.6859e-01  rd23lp=1.0000e+00   rd23s=-1.675e+00 \
 rd23sp=1.0000e+00    rd24=0.0000e+00    rd25=0.0000e+00 \
  gbmin=1.0000e-12
***************************************************************************
*                                Capacitances                             *
***************************************************************************
+    xqy=0.0000e+00    xqy1=0.0000e+00    xqy2=2.0000e+00 \
vfbover=-1.000e+00   qovsm=2.0000e-01   ovslp=2.0000e-08 \
  ovmag=5.0000e+02    cgso=2.0870e-10    cgdo=3.8610e-10 \
   cgbo=1.1000e-10   tpoly=2.0000e-07
***************************************************************************
*                              Leakage Currents                           *
***************************************************************************
+   sub1=5.0000e-02   sub1l=2.5000e-03  sub1lp=1.0000e+00 \
   sub2=3.0048e+01   sub2l=2.0000e-06    svds=8.0000e-01 \
    slg=3.0000e-08    slgl=0.0000e+00   slglp=1.0000e+00 \
   svbs=5.0000e-01   svbsl=0.0000e+00  svbslp=1.0000e+00 \
   svgs=8.0000e-01   svgsl=0.0000e+00  svgslp=1.0000e+00 \
  svgsw=0.0000e+00  svgswp=1.0000e+00   ibpc1=0.0000e+00 \
  ibpc2=0.0000e+00  subld1=0.0000e+00  subld2=0.0000e+00 \
 gleak1=5.0000e+01  gleak2=1.0000e+07  gleak3=6.0000e-02 \
 gleak4=4.0000e+00  gleak5=7.5000e+03  gleak6=2.5000e-01 \
 gleak7=1.0000e-06   glkb1=5.0000e-16   glkb2=1.0000e+00 \
  glkb3=0.0000e+00  glksd1=1.0000e-15  glksd2=1.0000e-02 \
 glksd3=-1.000e-02 glpart1=5.0000e-01     fn1=0.0000e+00 \
    fn2=0.0000e+00     fn3=0.0000e+00    fvbs=0.0000e+00 \
  gidl1=2.0000e+00   gidl2=3.0000e+07   gidl3=9.0000e-01 \
  gidl4=9.0000e-01   gidl5=2.0000e-01
***************************************************************************
*                             S/B and D/B Diodes                          *
***************************************************************************
+    js0=3.0890e-07   js0sw=1.1310e-13      nj=1.0000e+00 \
   njsw=1.0000e+00     xti=3.8400e+00    xti2=3.8400e+00 \
   divx=0.0000e+00    cisb=0.0000e+00     cvb=0.0000e+00 \
  ctemp=0.0000e+00   cisbk=0.0000e+00    cvbk=0.0000e+00 \
     cj=1.3600e-03    cjsw=3.5000e-10   cjswg=3.5000e-10 \
     mj=5.4000e-01    mjsw=4.6000e-01   mjswg=4.6000e-01 \
     pb=1.0200e+00    pbsw=1.0200e+00   pbswg=1.0200e+00 \
 vdiffj=6.0000e-04
***************************************************************************
*                                   Noise                                 *
***************************************************************************
+  nftrp=3.2435e+07   nfalp=1.5485e-18     cit=0.0000e+00 \
  falph=1.0000e+00
***************************************************************************
*                           Non Quasi Static Model                        *
***************************************************************************
+   dly1=1.0000e-10    dly2=7.0000e-01    dly3=8.0000e-07 \
  dlyov=0.0000e+00
***************************************************************************
*                            Self heating Effect                          *
***************************************************************************
+   rth0=5.5684e-01    cth0=1.0000e-07   rth0w=-8.500e+00 \
 rth0wp=1.0000e+00  rth0nf=0.0000e+00
***************************************************************************
*                                   DFM                                   *
***************************************************************************
+ mphdfm=-3.000e-01
***************************************************************************
*                         Additional Node                                 *
***************************************************************************
+ pzadd0=5.0000e-03  vzadd0=1.0000e-02 \
 rdict1=1.0000e+00  rdict2=0.0000e+00  rdvdlp=1.0000e+00 \
 vbsmin=-1.050e+01  rdslp2=1.0000e+00
***************************************************************************
*                         Additional Node                                 *
***************************************************************************
+ rdvsub=3.0000e-01 rdvdsub=1.0000e+00  ddrift=1.0000e-06 \
 vbisub=7.0000e-01 nsubsub=1.0000e+15
ends modp30m
//

inline subckt modp30mpd ( a c )
parameters area=1.0e-12 perimeter=1.0e-6
modp30mpd ( a c ) diodeinsub area=area perim=perimeter region=off
model diodeinsub diode level=1 dskip=no \
  is=6.1140e-07          isw=2.4910e-13 \
   n=1.0400e+00           ns=1.0400e+00 \
minr=0.100e+00          imax=(1.000e+00/area) \
 cj0=1.2340e-03           m=6.2660e-01 \
  vj=1.0200e+00           tt=0.000e+00 \
cjsw=2.8230e-10         mjsw=4.8760e-01 \
vjsw=1.0200e+00           fc=0.000e+00 \
  af=1.000e+00             kf=0.000e+00 \
 xti=2.7630e+00
ends modp30mpd
//

inline subckt modp30mnwd ( a c )
parameters area=1.0e-12 perimeter=1.0e-6
modp30mnwd ( a c ) diodeinsub area=area perim=perimeter region=off
model diodeinsub diode level=1 dskip=no \
  is=7.101e-06          isw=5.386e-12 \
   n=1.000e+00      ns=1.000e+00 \
minr=0.100e+00    imax=(1.000e+00/area) \
 cj0=3.850e-04           m=2.982e-01 \
  vj=5.300e-01          vjsw=5.300e-01 \
  fc=0.000e+00        tt=0.000e+00 \
cjsw=0.000e+00       mjsw=4.401e-01 \
  af=1.000e+00     kf=0.000e+00 \
 xti=-3.138e+00
ends modp30mnwd

// ----------------------------------------------------------------------
// Owner: austriamicrosystems
// HIT-Kit: Digital
// ************************ SIMULATION PARAMETERS ************************
//  ----------------------------------------------------------------------
//  format    : Spectre (Spectre Direct)
//  model     : MOS BSIM3v3
//  process   : C35
//  revision  : 1.0;
//  extracted : C18069; 28.08.2011; bse (5866)
//  doc#      : Eng-?? REV_0
//  ----------------------------------------------------------------------
//                    TYPICAL MEAN WORST NOISE CONDITION
//
//  ----------------------------------------------------------------------
//
inline subckt nmosw_2n ( d g s b )
parameters w=1.0e-6 l=1.0e-6 nrd=0.0 nrs=0.0 ad=0.0 as=0.0 pd=0.0 ps=0.0 ng=1
+ ws= w
+ ls= l
+ shk=1
+ dvthmat=(mv_nmosw_2n)*(0.67e-08/sqrt(ls*ws*ng)) dumat=(mu_nmosw_2n)*(4.9e-9/sqrt(ls*ws*ng))
//
if (modn==1)
nmosw_2n ( d g s b ) mosinsub w=ws l=ls nrd=8.0000e-07/ws nrs=8.0000e-07/ws ad=ad as=as pd=pd ps=ps m=ng
else
nmosw_2n ( d s ) resistor r=1e30
notvalid paramtest errorif=(modn==0) \
message="
***************************************************
*
* nmos is not valid in selected process option.
*
***************************************************"
model mosinsub bsim3v3 version=3.2400e+00  type=n  capmod=3.0000e+00 \
 mobmod=1.0000e+00  nqsmod=0.0000e+00  noimod=3.0000e+00 \
   vbox=1.000e+03      k1=5.9200e-01 \
     k2=0.0000e+00      k3=3.0270e-02     k3b=-1.089e-02 \
    nch=2.1870e+17 vth0=4.5000e-01+dvthmat \
   voff=-7.600e-02    dvt0=2.1160e+01    dvt1=1.0640e+00 \
   dvt2=3.0590e-02    keta=-1.200e-02 \
 pscbe1=1.0000e+30  pscbe2=1.0000e-06 \
 alpha0=1.9040e-06  alpha1=2.5000e+00   beta0=2.0000e+01 \
  dvt0w=2.0000e+00   dvt1w=1.6970e+06   dvt2w=-1.556e-02 \
     ua=-3.981e-10      ub=2.6890e-18      uc=6.9180e-11 \
u0=4.2200e+02+(4.2200e+02)*dumat \
   dsub=5.0000e-01    eta0=1.4790e-02    etab=-5.280e-02 \
nfactor=2.6780e-01 \
     em=4.1000e+07    pclm=9.6570e-01 \
  drout=5.0000e-01 \
     a0=2.0840e+00      a1=0.0000e+00      a2=1.0000e+00 \
   pvag=1.3460e-01    vsat=1.0200e+05     ags=3.6080e-01      b0=5.0200e-08      b1=1.0060e-07 \
  delta=2.3500e-03 pdiblcb=3.2150e-01 \
pdiblc1=1.0800e-01 pdiblc2=1.6220e-03 \
     w0=-3.185e-07 \
    dlc=-1.588e-08 \
dwc=-3.263e-01*l+1.5050e-07    dwb=0.0000e+00     dwg=-9.302e-09 \
     ll=1.0680e-13      lw=0.0000e+00     lwl=0.0000e+00 \
    lln=1.0000e+00     lwn=1.0000e+00      wl=2.8610e-13 \
     ww=-1.130e-14     wwl=-9.411e-21     wln=1.0000e+00 \
    wwn=1.0000e+00 \
     at=2.5000e+04     ute=-1.700e+00 \
    kt1=-3.100e-01     kt2=-1.720e-02    kt1l=0.0000e+00 \
    ua1=0.0000e+00     ub1=0.0000e+00     uc1=0.0000e+00 \
    prt=3.0000e+01 \
   cgso=1.0850e-12    cgdo=1.0850e-12    cgbo=1.7000e-08 \
   cgdl=2.8530e-10    cgsl=2.8530e-10  ckappa=2.6020e+00 \
     cf=0.0000e+00     elm=5.0000e+00 \
  xpart=1.0000e+00     clc=1.0000e-15     cle=6.0000e-01 \
\
   rdsw=1.1390e+03 \
   cdsc=0.0000e+00   cdscb=1.5000e-09   cdscd=0.0000e+00 \
   prwb=-5.000e-02    prwg=1.3340e-02     cit=8.0260e-04 \
tox=7.6700e-09 \
  ngate=1.0000e+00 \
    nlx=1.7000e-07 \
     xl=0.0000e+00      xw=0.0000e+00 \
     af=1.3760e+00      kf=3.3960e-26      ef=1.0000e+00 \
   noia=1.3990e+20    noib=2.7070e+05    noic=-4.680e-12 \
     rd=0.0000e+00      rs=0.0000e+00     rsh=7.5000e+01 \
   minr=1.000e-03 \
    rdc=0.0000e+00     rsc=0.0000e+00 lint=-3.098e-07 \
wint=-8.969e-07   ldif=0.000e+00    hdif=8.0000e-07 \
     xj=3.0000e-07      js=5.1000e-07 \
      n=1.0000e+00 \
  dskip=no          tlev=0           tlevc=0         \
    jsw=6.0000e-13 \
     cj=8.3000e-04    cjsw=2.5000e-10 \
     fc=0.0000e+00    fcsw=0.000e+00 \
     mj=3.4000e-01    mjsw=2.3000e-01 \
     pb=6.9000e-01    pbsw=6.9000e-01     xti=2.0300e+00
ends nmosw_2n

// ----------------------------------------------------------------------

// ----------------------------------------------------------------------
// Owner: austriamicrosystems
// HIT-Kit: Digital
// ************************ SIMULATION PARAMETERS ************************
//  ----------------------------------------------------------------------
//  format    : Spectre (Spectre Direct)
//  model     : MOS BSIM3v3
//  process   : C35
//  revision  : 1.0;
//  extracted : C18069; 28.08.2011; bse (5866)
//  doc#      : Eng-?? REV_0
//  ----------------------------------------------------------------------
//                    TYPICAL MEAN WORST NOISE CONDITION
//
//  ----------------------------------------------------------------------
//
inline subckt nmosw_3n ( d g s b )
parameters w=1.0e-6 l=1.0e-6 nrd=0.0 nrs=0.0 ad=0.0 as=0.0 pd=0.0 ps=0.0 ng=1
+ ws= w
+ ls= l
+ shk=1
+ dvthmat=(mv_nmosw_3n)*(0.67e-08/sqrt(ls*ws*ng)) dumat=(mu_nmosw_3n)*(4.9e-9/sqrt(ls*ws*ng))
//
if (modn==1)
nmosw_3n ( d g s b ) mosinsub w=ws l=ls nrd=8.0000e-07/ws nrs=8.0000e-07/ws ad=ad as=as pd=pd ps=ps m=ng
else
nmosw_3n ( d s ) resistor r=1e30
notvalid paramtest errorif=(modn==0) \
message="
***************************************************
*
* nmos is not valid in selected process option.
*
***************************************************"
model mosinsub bsim3v3 version=3.2400e+00  type=n  capmod=3.0000e+00 \
 mobmod=1.0000e+00  nqsmod=0.0000e+00  noimod=3.0000e+00 \
   vbox=1.000e+03      k1=5.9200e-01 \
     k2=0.0000e+00      k3=3.0270e-02     k3b=-1.089e-02 \
    nch=2.1870e+17 vth0=4.5000e-01+dvthmat \
   voff=-7.600e-02    dvt0=2.1160e+01    dvt1=1.0640e+00 \
   dvt2=3.0590e-02    keta=-1.200e-02 \
 pscbe1=1.0000e+30  pscbe2=1.0000e-06 \
 alpha0=1.9040e-06  alpha1=2.5000e+00   beta0=2.0000e+01 \
  dvt0w=2.0000e+00   dvt1w=1.6970e+06   dvt2w=-1.556e-02 \
     ua=-3.981e-10      ub=2.6890e-18      uc=6.9180e-11 \
u0=4.2200e+02+(4.2200e+02)*dumat \
   dsub=5.0000e-01    eta0=1.4790e-02    etab=-5.280e-02 \
nfactor=2.6780e-01 \
     em=4.1000e+07    pclm=9.6570e-01 \
  drout=5.0000e-01 \
     a0=2.0840e+00      a1=0.0000e+00      a2=1.0000e+00 \
   pvag=1.3460e-01    vsat=1.0200e+05     ags=3.6080e-01      b0=5.0200e-08      b1=1.0060e-07 \
  delta=2.3500e-03 pdiblcb=3.2150e-01 \
pdiblc1=2.3600e-01 pdiblc2=2.4880e-03 \
     w0=-3.185e-07 \
    dlc=-1.588e-08 \
dwc=-3.263e-01*l+1.5050e-07    dwb=0.0000e+00     dwg=-9.302e-09 \
     ll=1.0680e-13      lw=0.0000e+00     lwl=0.0000e+00 \
    lln=1.0000e+00     lwn=1.0000e+00      wl=2.8610e-13 \
     ww=-1.130e-14     wwl=-9.411e-21     wln=1.0000e+00 \
    wwn=1.0000e+00 \
     at=2.5000e+04     ute=-1.700e+00 \
    kt1=-3.100e-01     kt2=-1.720e-02    kt1l=0.0000e+00 \
    ua1=0.0000e+00     ub1=0.0000e+00     uc1=0.0000e+00 \
    prt=3.0000e+01 \
   cgso=1.0850e-12    cgdo=1.0850e-12    cgbo=1.7000e-08 \
   cgdl=2.8530e-10    cgsl=2.8530e-10  ckappa=2.6020e+00 \
     cf=0.0000e+00     elm=5.0000e+00 \
  xpart=1.0000e+00     clc=1.0000e-15     cle=6.0000e-01 \
\
   rdsw=1.1390e+03 \
   cdsc=0.0000e+00   cdscb=1.5000e-09   cdscd=0.0000e+00 \
   prwb=-1.471e-01    prwg=1.3340e-02     cit=8.0260e-04 \
tox=7.6700e-09 \
  ngate=1.0000e+00 \
    nlx=1.7000e-07 \
     xl=0.0000e+00      xw=0.0000e+00 \
     af=1.3760e+00      kf=3.3960e-26      ef=1.0000e+00 \
   noia=1.3990e+20    noib=2.7070e+05    noic=-4.680e-12 \
     rd=0.0000e+00      rs=0.0000e+00     rsh=7.5000e+01 \
   minr=1.000e-03 \
    rdc=0.0000e+00     rsc=0.0000e+00 lint=-3.098e-07 \
wint=-8.216e-07   ldif=0.000e+00    hdif=8.0000e-07 \
     xj=3.0000e-07      js=5.1000e-07 \
      n=1.0000e+00 \
  dskip=no          tlev=0           tlevc=0         \
    jsw=6.0000e-13 \
     cj=8.3000e-04    cjsw=2.5000e-10 \
     fc=0.0000e+00    fcsw=0.000e+00 \
     mj=3.4000e-01    mjsw=2.3000e-01 \
     pb=6.9000e-01    pbsw=6.9000e-01     xti=2.0300e+00
ends nmosw_3n

// ----------------------------------------------------------------------

// ----------------------------------------------------------------------
// Owner: austriamicrosystems
// HIT-Kit: Digital
// ************************ SIMULATION PARAMETERS ************************
//  ----------------------------------------------------------------------
//  format    : Spectre (Spectre Direct)
//  model     : MOS BSIM3v3
//  process   : C35
//  revision  : 1.0;
//  extracted : C18069; 28.08.2011; bse (5866)
//  doc#      : Eng-?? REV_0
//  ----------------------------------------------------------------------
//                    TYPICAL MEAN WORST NOISE CONDITION
//
//  ----------------------------------------------------------------------
//
inline subckt nmosw_4n ( d g s b )
parameters w=1.0e-6 l=1.0e-6 nrd=0.0 nrs=0.0 ad=0.0 as=0.0 pd=0.0 ps=0.0 ng=1
+ ws= w
+ ls= l
+ shk=1
+ dvthmat=(mv_nmosw_4n)*(0.67e-08/sqrt(ls*ws*ng)) dumat=(mu_nmosw_4n)*(4.9e-9/sqrt(ls*ws*ng))
//
if (modn==1)
nmosw_4n ( d g s b ) mosinsub w=ws l=ls nrd=8.0000e-07/ws nrs=8.0000e-07/ws ad=ad as=as pd=pd ps=ps m=ng
else
nmosw_4n ( d s ) resistor r=1e30
notvalid paramtest errorif=(modn==0) \
message="
***************************************************
*
* nmos is not valid in selected process option.
*
***************************************************"
model mosinsub bsim3v3 version=3.2400e+00  type=n  capmod=3.0000e+00 \
 mobmod=1.0000e+00  nqsmod=0.0000e+00  noimod=3.0000e+00 \
   vbox=1.000e+03      k1=5.9200e-01 \
     k2=0.0000e+00      k3=3.0270e-02     k3b=-1.089e-02 \
    nch=2.1870e+17 vth0=4.5000e-01+dvthmat \
   voff=-7.600e-02    dvt0=2.1160e+01    dvt1=1.0640e+00 \
   dvt2=3.0590e-02    keta=-1.200e-02 \
 pscbe1=1.0000e+30  pscbe2=1.0000e-06 \
 alpha0=1.9040e-06  alpha1=2.5000e+00   beta0=2.0000e+01 \
  dvt0w=2.0000e+00   dvt1w=1.6970e+06   dvt2w=-1.556e-02 \
     ua=-3.981e-10      ub=2.5120e-18      uc=6.9180e-11 \
u0=4.2200e+02+(4.2200e+02)*dumat \
   dsub=5.0000e-01    eta0=1.4790e-02    etab=-5.280e-02 \
nfactor=2.6780e-01 \
     em=4.1000e+07    pclm=9.6570e-01 \
  drout=5.0000e-01 \
     a0=2.0840e+00      a1=0.0000e+00      a2=1.0000e+00 \
   pvag=1.3460e-01    vsat=1.0200e+05     ags=3.1620e-01      b0=5.0200e-08      b1=1.0060e-07 \
  delta=2.3500e-03 pdiblcb=3.2150e-01 \
pdiblc1=8.3400e-01 pdiblc2=2.4880e-03 \
     w0=-3.185e-07 \
    dlc=-1.588e-08 \
dwc=-3.263e-01*l+1.5050e-07    dwb=0.0000e+00     dwg=-9.302e-09 \
     ll=0.0000e+00      lw=0.0000e+00     lwl=0.0000e+00 \
    lln=1.0000e+00     lwn=1.0000e+00      wl=-1.924e-13 \
     ww=0.0000e+00     wwl=0.0000e+00     wln=1.0000e+00 \
    wwn=1.0000e+00 \
     at=2.5000e+04     ute=-1.700e+00 \
    kt1=-3.100e-01     kt2=-1.720e-02    kt1l=0.0000e+00 \
    ua1=0.0000e+00     ub1=0.0000e+00     uc1=0.0000e+00 \
    prt=-2.456e+02 \
   cgso=1.0850e-12    cgdo=1.0850e-12    cgbo=1.7000e-08 \
   cgdl=2.8530e-10    cgsl=2.8530e-10  ckappa=2.6020e+00 \
     cf=0.0000e+00     elm=5.0000e+00 \
  xpart=1.0000e+00     clc=1.0000e-15     cle=6.0000e-01 \
\
   rdsw=1.1410e+03 \
   cdsc=0.0000e+00   cdscb=1.5000e-09   cdscd=0.0000e+00 \
   prwb=-7.244e-02    prwg=1.1740e-01     cit=8.0260e-04 \
tox=7.6700e-09 \
  ngate=1.0000e+00 \
    nlx=1.7000e-07 \
     xl=0.0000e+00      xw=0.0000e+00 \
     af=1.3760e+00      kf=3.3960e-26      ef=1.0000e+00 \
   noia=1.3990e+20    noib=2.7070e+05    noic=-4.680e-12 \
     rd=0.0000e+00      rs=0.0000e+00     rsh=7.5000e+01 \
   minr=1.000e-03 \
    rdc=0.0000e+00     rsc=0.0000e+00 lint=-1.868e-07 \
wint=-3.544e-07   ldif=0.000e+00    hdif=8.0000e-07 \
     xj=3.0000e-07      js=5.1000e-07 \
      n=1.0000e+00 \
  dskip=no          tlev=0           tlevc=0         \
    jsw=6.0000e-13 \
     cj=8.3000e-04    cjsw=2.5000e-10 \
     fc=0.0000e+00    fcsw=0.000e+00 \
     mj=3.4000e-01    mjsw=2.3000e-01 \
     pb=6.9000e-01    pbsw=6.9000e-01     xti=2.0300e+00
ends nmosw_4n

// ----------------------------------------------------------------------

// ----------------------------------------------------------------------
// Owner: austriamicrosystems
// HIT-Kit: Digital
// ************************ SIMULATION PARAMETERS ************************
//  ----------------------------------------------------------------------
//  format    : Spectre (Spectre Direct)
//  model     : MOS BSIM3v3
//  process   : C35
//  revision  : 1.0;
//  extracted : C18069; 28.08.2011; bse (5866)
//  doc#      : Eng-?? REV_0
//  ----------------------------------------------------------------------
//                    TYPICAL MEAN WORST NOISE CONDITION
//
//  ----------------------------------------------------------------------
//
inline subckt nmosmw_2n ( d g s b )
parameters w=1.0e-6 l=1.0e-6 nrd=0.0 nrs=0.0 ad=0.0 as=0.0 pd=0.0 ps=0.0 ng=1
+ ws= w
+ ls= l
+ shk=1
+ dvthmat=(mv_nmosmw_2n)*(1.03e-08/sqrt(ls*ws*ng)) dumat=(mu_nmosmw_2n)*(3.5e-9/sqrt(ls*ws*ng))
//
if (modnm==1)
nmosmw_2n ( d g s b ) mosinsub w=ws l=ls nrd=6.0000e-07/ws nrs=6.0000e-07/ws ad=ad as=as pd=pd ps=ps m=ng
else
nmosmw_2n ( d s ) resistor r=1e30
notvalid paramtest errorif=(modnm==0) \
message="
***************************************************
*
* nmosm is not valid in selected process option.
*
***************************************************"
model mosinsub bsim3v3 version=3.2400e+00  type=n  capmod=3.0000e+00 \
 mobmod=1.0000e+00  nqsmod=0.0000e+00  noimod=3.0000e+00 \
   vbox=1.000e+03      k1=1.0000e+00 \
     k2=0.0000e+00      k3=-2.500e+00     k3b=-5.640e-02 \
    nch=1.4460e+17 vth0=7.1900e-01+dvthmat \
   voff=-9.684e-02    dvt0=2.0510e+01    dvt1=1.0610e+00 \
   dvt2=2.5970e-02    keta=3.2000e-02 \
 pscbe1=1.0000e+30  pscbe2=1.0000e-06 \
 alpha0=5.5350e-08  alpha1=1.3930e-01   beta0=1.9570e+01 \
  dvt0w=1.0800e+01   dvt1w=3.0990e+06   dvt2w=1.4520e-01 \
     ua=1.4200e-12      ub=1.7380e-18      uc=5.7540e-11 \
u0=5.0600e+02+(5.0600e+02)*dumat \
   dsub=5.0000e-01    eta0=4.0860e-02    etab=-1.000e-03 \
nfactor=8.6050e-01 \
     em=4.1000e+07    pclm=9.0000e-01 \
  drout=5.0000e-01 \
     a0=1.0000e+00      a1=0.0000e+00      a2=1.0000e+00 \
   pvag=6.0000e-02    vsat=5.3380e+04     ags=1.9140e-01      b0=2.0000e-08      b1=1.0000e-08 \
  delta=1.0000e-02 pdiblcb=9.7980e-01 \
pdiblc1=2.4800e-01 pdiblc2=1.2400e-03 \
     w0=3.3160e-08 \
    dlc=1.3960e-09 \
dwc=-2.884e-01*l+1.4740e-07    dwb=8.6800e-09     dwg=-3.770e-09 \
     ll=7.4510e-14      lw=0.0000e+00     lwl=0.0000e+00 \
    lln=1.0000e+00     lwn=1.0000e+00      wl=-3.626e-13 \
     ww=-1.514e-14     wwl=-1.321e-20     wln=1.0000e+00 \
    wwn=1.0000e+00 \
     at=3.3000e+04     ute=-1.720e+00 \
    kt1=-4.180e-01     kt2=-4.560e-02    kt1l=0.0000e+00 \
    ua1=0.0000e+00     ub1=0.0000e+00     uc1=0.0000e+00 \
    prt=0.0000e+00 \
   cgso=1.0050e-10    cgdo=1.0050e-10    cgbo=1.6000e-08 \
   cgdl=1.0000e-10    cgsl=1.0000e-10  ckappa=2.9570e+00 \
     cf=0.0000e+00     elm=5.0000e+00 \
  xpart=1.0000e+00     clc=1.0000e-15     cle=6.0000e-01 \
\
   rdsw=3.0420e+03 \
   cdsc=0.0000e+00   cdscb=2.0000e-03   cdscd=0.0000e+00 \
   prwb=5.0000e-02    prwg=4.3480e-03     cit=0.0000e+00 \
tox=1.5000e-08 \
  ngate=1.0000e+00 \
    nlx=1.5690e-07 \
     xl=0.0000e+00      xw=0.0000e+00 \
     af=1.3580e+00      kf=3.4460e-26      ef=1.0000e+00 \
   noia=1.7020e+20    noib=5.4630e+05    noic=-1.400e-11 \
     rd=0.0000e+00      rs=0.0000e+00     rsh=7.9000e+01 \
   minr=1.000e-03 \
    rdc=0.0000e+00     rsc=0.0000e+00 lint=-3.093e-07 \
wint=-8.560e-07   ldif=0.000e+00    hdif=6.0000e-07 \
     xj=3.0000e-07      js=5.1000e-07 \
      n=1.0000e+00 \
  dskip=no          tlev=0           tlevc=0         \
    jsw=6.0000e-13 \
     cj=8.3000e-04    cjsw=2.5000e-10 \
     fc=0.0000e+00    fcsw=0.000e+00 \
     mj=3.4000e-01    mjsw=2.3000e-01 \
     pb=6.9000e-01    pbsw=6.9000e-01     xti=2.0300e+00
ends nmosmw_2n

// ----------------------------------------------------------------------

// ----------------------------------------------------------------------
// Owner: austriamicrosystems
// HIT-Kit: Digital
// ************************ SIMULATION PARAMETERS ************************
//  ----------------------------------------------------------------------
//  format    : Spectre (Spectre Direct)
//  model     : MOS BSIM3v3
//  process   : C35
//  revision  : 1.0;
//  extracted : C18069; 28.08.2011; bse (5866)
//  doc#      : Eng-?? REV_0
//  ----------------------------------------------------------------------
//                    TYPICAL MEAN WORST NOISE CONDITION
//
//  ----------------------------------------------------------------------
//
inline subckt nmosmw_3n ( d g s b )
parameters w=1.0e-6 l=1.0e-6 nrd=0.0 nrs=0.0 ad=0.0 as=0.0 pd=0.0 ps=0.0 ng=1
+ ws= w
+ ls= l
+ shk=1
+ dvthmat=(mv_nmosmw_3n)*(1.03e-08/sqrt(ls*ws*ng)) dumat=(mu_nmosmw_3n)*(3.5e-9/sqrt(ls*ws*ng))
//
if (modnm==1)
nmosmw_3n ( d g s b ) mosinsub w=ws l=ls nrd=6.0000e-07/ws nrs=6.0000e-07/ws ad=ad as=as pd=pd ps=ps m=ng
else
nmosmw_3n ( d s ) resistor r=1e30
notvalid paramtest errorif=(modnm==0) \
message="
***************************************************
*
* nmosm is not valid in selected process option.
*
***************************************************"
model mosinsub bsim3v3 version=3.2400e+00  type=n  capmod=3.0000e+00 \
 mobmod=1.0000e+00  nqsmod=0.0000e+00  noimod=3.0000e+00 \
   vbox=1.000e+03      k1=1.0000e+00 \
     k2=0.0000e+00      k3=-2.500e+00     k3b=-5.640e-02 \
    nch=1.4460e+17 vth0=7.1900e-01+dvthmat \
   voff=-9.684e-02    dvt0=2.0510e+01    dvt1=1.0610e+00 \
   dvt2=2.5970e-02    keta=3.2000e-02 \
 pscbe1=1.0000e+30  pscbe2=1.0000e-06 \
 alpha0=5.5350e-08  alpha1=1.3930e-01   beta0=1.9570e+01 \
  dvt0w=1.0800e+01   dvt1w=3.0990e+06   dvt2w=1.4520e-01 \
     ua=1.4200e-12      ub=1.7380e-18      uc=5.7540e-11 \
u0=5.0600e+02+(5.0600e+02)*dumat \
   dsub=5.0000e-01    eta0=4.0860e-02    etab=-1.000e-03 \
nfactor=8.6050e-01 \
     em=4.1000e+07    pclm=9.0000e-01 \
  drout=5.0000e-01 \
     a0=1.0000e+00      a1=0.0000e+00      a2=1.0000e+00 \
   pvag=6.0000e-02    vsat=6.1710e+04     ags=1.9140e-01      b0=2.0000e-08      b1=1.0000e-08 \
  delta=1.0000e-02 pdiblcb=9.7980e-01 \
pdiblc1=1.4000e-01 pdiblc2=1.3490e-03 \
     w0=3.3160e-08 \
    dlc=1.3960e-09 \
dwc=-2.884e-01*l+1.4740e-07    dwb=8.6800e-09     dwg=-3.770e-09 \
     ll=7.4510e-14      lw=0.0000e+00     lwl=0.0000e+00 \
    lln=1.0000e+00     lwn=1.0000e+00      wl=-1.968e-13 \
     ww=-1.514e-14     wwl=-1.321e-20     wln=1.0000e+00 \
    wwn=1.0000e+00 \
     at=3.3000e+04     ute=-1.720e+00 \
    kt1=-4.180e-01     kt2=-4.560e-02    kt1l=0.0000e+00 \
    ua1=0.0000e+00     ub1=0.0000e+00     uc1=0.0000e+00 \
    prt=0.0000e+00 \
   cgso=1.0050e-10    cgdo=1.0050e-10    cgbo=1.6000e-08 \
   cgdl=1.0050e-10    cgsl=1.0050e-10  ckappa=2.9570e+00 \
     cf=0.0000e+00     elm=5.0000e+00 \
  xpart=1.0000e+00     clc=1.0000e-15     cle=6.0000e-01 \
\
   rdsw=2.5390e+03 \
   cdsc=0.0000e+00   cdscb=2.0000e-03   cdscd=0.0000e+00 \
   prwb=5.0000e-02    prwg=4.3480e-03     cit=0.0000e+00 \
tox=1.5000e-08 \
  ngate=1.0000e+00 \
    nlx=1.5690e-07 \
     xl=0.0000e+00      xw=0.0000e+00 \
     af=1.3580e+00      kf=3.4460e-26      ef=1.0000e+00 \
   noia=1.7020e+20    noib=5.4630e+05    noic=-1.400e-11 \
     rd=0.0000e+00      rs=0.0000e+00     rsh=7.9000e+01 \
   minr=1.000e-03 \
    rdc=0.0000e+00     rsc=0.0000e+00 lint=-2.609e-07 \
wint=-6.127e-07   ldif=0.000e+00    hdif=6.0000e-07 \
     xj=3.0000e-07      js=5.1000e-07 \
      n=1.0000e+00 \
  dskip=no          tlev=0           tlevc=0         \
    jsw=6.0000e-13 \
     cj=8.3000e-04    cjsw=2.5000e-10 \
     fc=0.0000e+00    fcsw=0.000e+00 \
     mj=3.4000e-01    mjsw=2.3000e-01 \
     pb=6.9000e-01    pbsw=6.9000e-01     xti=2.0300e+00
ends nmosmw_3n

// ----------------------------------------------------------------------

// ----------------------------------------------------------------------
// Owner: austriamicrosystems
// HIT-Kit: Digital
// ************************ SIMULATION PARAMETERS ************************
//  ----------------------------------------------------------------------
//  format    : Spectre (Spectre Direct)
//  model     : MOS BSIM3v3
//  process   : C35
//  revision  : 1.0;
//  extracted : C18069; 28.08.2011; bse (5866)
//  doc#      : Eng-?? REV_0
//  ----------------------------------------------------------------------
//                    TYPICAL MEAN WORST NOISE CONDITION
//
//  ----------------------------------------------------------------------
//
inline subckt nmosmw_4n ( d g s b )
parameters w=1.0e-6 l=1.0e-6 nrd=0.0 nrs=0.0 ad=0.0 as=0.0 pd=0.0 ps=0.0 ng=1
+ ws= w
+ ls= l
+ shk=1
+ dvthmat=(mv_nmosmw_4n)*(1.03e-08/sqrt(ls*ws*ng)) dumat=(mu_nmosmw_4n)*(3.5e-9/sqrt(ls*ws*ng))
//
if (modnm==1)
nmosmw_4n ( d g s b ) mosinsub w=ws l=ls nrd=6.0000e-07/ws nrs=6.0000e-07/ws ad=ad as=as pd=pd ps=ps m=ng
else
nmosmw_4n ( d s ) resistor r=1e30
notvalid paramtest errorif=(modnm==0) \
message="
***************************************************
*
* nmosm is not valid in selected process option.
*
***************************************************"
model mosinsub bsim3v3 version=3.2400e+00  type=n  capmod=3.0000e+00 \
 mobmod=1.0000e+00  nqsmod=0.0000e+00  noimod=3.0000e+00 \
   vbox=1.000e+03      k1=1.0000e+00 \
     k2=0.0000e+00      k3=-2.500e+00     k3b=-5.640e-02 \
    nch=1.4460e+17 vth0=7.1900e-01+dvthmat \
   voff=-9.684e-02    dvt0=2.0510e+01    dvt1=1.0610e+00 \
   dvt2=2.5970e-02    keta=3.2000e-02 \
 pscbe1=1.0000e+30  pscbe2=1.0000e-06 \
 alpha0=5.5350e-08  alpha1=1.3930e-01   beta0=1.9570e+01 \
  dvt0w=1.0800e+01   dvt1w=3.0990e+06   dvt2w=1.4520e-01 \
     ua=4.5710e-10      ub=1.7380e-18      uc=5.7540e-11 \
u0=5.0600e+02+(5.0600e+02)*dumat \
   dsub=5.0000e-01    eta0=4.0860e-02    etab=-1.000e-03 \
nfactor=8.6050e-01 \
     em=4.1000e+07    pclm=9.0000e-01 \
  drout=5.0000e-01 \
     a0=1.0000e+00      a1=0.0000e+00      a2=1.0000e+00 \
   pvag=6.0000e-02    vsat=6.3000e+04     ags=1.4990e-01      b0=2.0000e-08      b1=1.0000e-08 \
  delta=1.0000e-02 pdiblcb=9.7980e-01 \
pdiblc1=3.2000e-02 pdiblc2=1.6680e-03 \
     w0=3.3160e-08 \
    dlc=1.3960e-09 \
dwc=-2.884e-01*l+1.4740e-07    dwb=8.6800e-09     dwg=-3.770e-09 \
     ll=6.7850e-14      lw=0.0000e+00     lwl=0.0000e+00 \
    lln=1.0000e+00     lwn=1.0000e+00      wl=-1.989e-13 \
     ww=-1.514e-14     wwl=-1.321e-20     wln=1.0000e+00 \
    wwn=1.0000e+00 \
     at=3.3000e+04     ute=-1.720e+00 \
    kt1=-4.180e-01     kt2=-4.560e-02    kt1l=0.0000e+00 \
    ua1=0.0000e+00     ub1=0.0000e+00     uc1=0.0000e+00 \
    prt=0.0000e+00 \
   cgso=1.0050e-10    cgdo=1.0050e-10    cgbo=1.6000e-08 \
   cgdl=1.0000e-10    cgsl=1.0000e-10  ckappa=2.9570e+00 \
     cf=0.0000e+00     elm=5.0000e+00 \
  xpart=1.0000e+00     clc=1.0000e-15     cle=6.0000e-01 \
\
   rdsw=2.7670e+03 \
   cdsc=0.0000e+00   cdscb=2.0000e-03   cdscd=0.0000e+00 \
   prwb=2.0000e-02    prwg=1.0000e-02     cit=0.0000e+00 \
tox=1.5000e-08 \
  ngate=1.0000e+00 \
    nlx=1.5690e-07 \
     xl=0.0000e+00      xw=0.0000e+00 \
     af=1.3580e+00      kf=3.4460e-26      ef=1.0000e+00 \
   noia=1.7020e+20    noib=5.4630e+05    noic=-1.400e-11 \
     rd=0.0000e+00      rs=0.0000e+00     rsh=7.9000e+01 \
   minr=1.000e-03 \
    rdc=0.0000e+00     rsc=0.0000e+00 lint=-2.104e-07 \
wint=-7.006e-07   ldif=0.000e+00    hdif=6.0000e-07 \
     xj=3.0000e-07      js=5.1000e-07 \
      n=1.0000e+00 \
  dskip=no          tlev=0           tlevc=0         \
    jsw=6.0000e-13 \
     cj=8.3000e-04    cjsw=2.5000e-10 \
     fc=0.0000e+00    fcsw=0.000e+00 \
     mj=3.4000e-01    mjsw=2.3000e-01 \
     pb=6.9000e-01    pbsw=6.9000e-01     xti=2.0300e+00
ends nmosmw_4n

// ----------------------------------------------------------------------

// ----------------------------------------------------------------------
// Owner: austriamicrosystems
// HIT-Kit: Digital
// ************************ SIMULATION PARAMETERS ************************
//  ----------------------------------------------------------------------
//  format    : Spectre (Spectre Direct)
//  model     : MOS BSIM3v3
//  process   : C35
//  revision  : 1.0;
//  extracted : C18069; 28.08.2011; bse (5866)
//  doc#      : Eng-?? REV_0
//  ----------------------------------------------------------------------
//                    TYPICAL MEAN WORST NOISE CONDITION
//
//  ----------------------------------------------------------------------
//
inline subckt pmosw_2n ( d g s b )
parameters w=1.0e-6 l=1.0e-6 nrd=0.0 nrs=0.0 ad=0.0 as=0.0 pd=0.0 ps=0.0 ng=1
+ ws= w
+ ls= l
+ shk=1
+ dvthmat=(mv_pmosw_2n)*(1.03e-08/sqrt(ls*ws*ng)) dumat=(mu_pmosw_2n)*(4.89e-9/sqrt(ls*ws*ng))
//
if (modp==1)
pmosw_2n ( d g s b ) mosinsub w=ws l=ls nrd=8.0000e-07/ws nrs=8.0000e-07/ws ad=ad as=as pd=pd ps=ps m=ng
else
pmosw_2n ( d s ) resistor r=1e30
notvalid paramtest errorif=(modp==0) \
message="
***************************************************
*
* pmos is not valid in selected process option.
*
***************************************************"
model mosinsub bsim3v3 version=3.2400e+00  type=p  capmod=3.0000e+00 \
 mobmod=1.0000e+00  nqsmod=0.0000e+00  noimod=3.0000e+00 \
   vbox=1.000e+03      k1=3.3100e-01 \
     k2=0.0000e+00      k3=5.2000e+00     k3b=-1.000e+00 \
    nch=9.2400e+16 vth0=-7.440e-01+dvthmat \
   voff=-1.640e-01    dvt0=2.2000e+00    dvt1=6.3470e-01 \
   dvt2=5.3690e-02    keta=-7.600e-03 \
 pscbe1=1.0000e+30  pscbe2=1.0000e-06 \
 alpha0=1.0000e-09  alpha1=1.1750e-02   beta0=2.2870e+01 \
  dvt0w=1.0090e-01   dvt1w=7.3400e+04   dvt2w=-6.310e-03 \
     ua=4.1690e-10      ub=1.9050e-18      uc=-3.631e-11 \
u0=1.7300e+02+(1.7300e+02)*dumat \
   dsub=5.0000e-01    eta0=2.4000e-01    etab=-3.917e-03 \
nfactor=1.0000e+00 \
     em=4.1000e+07    pclm=3.3380e+00 \
  drout=5.0000e-01 \
     a0=9.0000e-01      a1=1.4440e-15      a2=5.0780e-01 \
   pvag=1.0000e-03    vsat=6.0900e+04     ags=2.1480e-01      b0=2.1920e-07      b1=0.0000e+00 \
  delta=1.0000e-02 pdiblcb=1.0000e-02 \
pdiblc1=8.9340e+02 pdiblc2=1.8000e-03 \
     w0=-1.500e-07 \
    dlc=-2.929e-08 \
dwc=-3.000e-01*l+1.5000e-07    dwb=-5.244e-09     dwg=-1.100e-08 \
     ll=3.5530e-15      lw=0.0000e+00     lwl=0.0000e+00 \
    lln=1.0000e+00     lwn=1.0000e+00      wl=-1.712e-12 \
     ww=-4.300e-14     wwl=-2.884e-21     wln=1.0000e+00 \
    wwn=1.0000e+00 \
     at=3.3000e+04     ute=-1.300e+00 \
    kt1=-4.740e-01     kt2=-5.440e-02    kt1l=-1.600e-08 \
    ua1=0.0000e+00     ub1=-3.802e-19     uc1=0.0000e+00 \
    prt=0.0000e+00 \
   cgso=9.0000e-11    cgdo=9.0000e-11    cgbo=1.7000e-08 \
   cgdl=1.3550e-10    cgsl=1.3550e-10  ckappa=1.0000e-01 \
     cf=0.0000e+00     elm=5.0000e+00 \
  xpart=1.0000e+00     clc=1.0000e-15     cle=6.0000e-01 \
\
   rdsw=1.0660e+04 \
   cdsc=1.2000e-02   cdscb=9.0000e-03   cdscd=1.0000e-03 \
   prwb=1.9620e-02    prwg=-3.558e-02     cit=0.0000e+00 \
tox=7.7540e-09 \
  ngate=0.0000e+00 \
    nlx=3.0770e-08 \
     xl=0.0000e+00      xw=0.0000e+00 \
     af=1.4050e+00      kf=1.8270e-26      ef=1.0000e+00 \
   noia=7.0910e+18    noib=6.0740e+04    noic=3.7790e-13 \
     rd=0.0000e+00      rs=0.0000e+00     rsh=1.2900e+02 \
   minr=1.000e-03 \
    rdc=0.0000e+00     rsc=0.0000e+00 lint=-7.965e-07 \
wint=-1.959e-06   ldif=0.000e+00    hdif=8.0000e-07 \
     xj=3.0000e-07      js=2.8000e-07 \
      n=1.0000e+00 \
  dskip=no          tlev=0           tlevc=0         \
    jsw=3.7000e-13 \
     cj=1.3600e-03    cjsw=3.5000e-10 \
     fc=0.0000e+00    fcsw=0.000e+00 \
     mj=5.4000e-01    mjsw=4.6000e-01 \
     pb=1.0200e+00    pbsw=1.0200e+00     xti=1.9730e+00
ends pmosw_2n

// ----------------------------------------------------------------------

// ----------------------------------------------------------------------
// Owner: austriamicrosystems
// HIT-Kit: Digital
// ************************ SIMULATION PARAMETERS ************************
//  ----------------------------------------------------------------------
//  format    : Spectre (Spectre Direct)
//  model     : MOS BSIM3v3
//  process   : C35
//  revision  : 1.0;
//  extracted : C18069; 28.08.2011; bse (5866)
//  doc#      : Eng-?? REV_0
//  ----------------------------------------------------------------------
//                    TYPICAL MEAN WORST NOISE CONDITION
//
//  ----------------------------------------------------------------------
//
inline subckt pmosw_3n ( d g s b )
parameters w=1.0e-6 l=1.0e-6 nrd=0.0 nrs=0.0 ad=0.0 as=0.0 pd=0.0 ps=0.0 ng=1
+ ws= w
+ ls= l
+ shk=1
+ dvthmat=(mv_pmosw_3n)*(1.03e-08/sqrt(ls*ws*ng)) dumat=(mu_pmosw_3n)*(4.89e-9/sqrt(ls*ws*ng))
//
if (modp==1)
pmosw_3n ( d g s b ) mosinsub w=ws l=ls nrd=8.0000e-07/ws nrs=8.0000e-07/ws ad=ad as=as pd=pd ps=ps m=ng
else
pmosw_3n ( d s ) resistor r=1e30
notvalid paramtest errorif=(modp==0) \
message="
***************************************************
*
* pmos is not valid in selected process option.
*
***************************************************"
model mosinsub bsim3v3 version=3.2400e+00  type=p  capmod=3.0000e+00 \
 mobmod=1.0000e+00  nqsmod=0.0000e+00  noimod=3.0000e+00 \
   vbox=1.000e+03      k1=3.3100e-01 \
     k2=0.0000e+00      k3=5.2000e+00     k3b=-1.000e+00 \
    nch=9.2400e+16 vth0=-7.440e-01+dvthmat \
   voff=-1.640e-01    dvt0=2.2000e+00    dvt1=6.3470e-01 \
   dvt2=5.3690e-02    keta=-7.600e-03 \
 pscbe1=1.0000e+30  pscbe2=1.0000e-06 \
 alpha0=1.0000e-09  alpha1=1.1750e-02   beta0=2.2870e+01 \
  dvt0w=1.0090e-01   dvt1w=7.3400e+04   dvt2w=-6.310e-03 \
     ua=4.1690e-10      ub=1.9050e-18      uc=-3.631e-11 \
u0=1.7300e+02+(1.7300e+02)*dumat \
   dsub=5.0000e-01    eta0=2.4000e-01    etab=-3.917e-03 \
nfactor=1.0000e+00 \
     em=4.1000e+07    pclm=3.5650e+00 \
  drout=5.0000e-01 \
     a0=9.0000e-01      a1=1.4440e-15      a2=5.0780e-01 \
   pvag=4.6400e+00    vsat=1.0000e+05     ags=3.8020e-01      b0=2.1920e-07      b1=0.0000e+00 \
  delta=1.0000e-02 pdiblcb=1.0000e+00 \
pdiblc1=8.3320e+00 pdiblc2=2.0670e-03 \
     w0=-1.500e-07 \
    dlc=-2.929e-08 \
dwc=-3.000e-01*l+1.5000e-07    dwb=-5.244e-09     dwg=-1.100e-08 \
     ll=3.5530e-15      lw=0.0000e+00     lwl=0.0000e+00 \
    lln=1.0000e+00     lwn=1.0000e+00      wl=-5.064e-13 \
     ww=-4.300e-14     wwl=-2.884e-21     wln=1.0000e+00 \
    wwn=1.0000e+00 \
     at=3.3000e+04     ute=-1.300e+00 \
    kt1=-4.740e-01     kt2=-5.440e-02    kt1l=-1.600e-08 \
    ua1=0.0000e+00     ub1=-3.802e-19     uc1=0.0000e+00 \
    prt=0.0000e+00 \
   cgso=9.0000e-11    cgdo=9.0000e-11    cgbo=1.7000e-08 \
   cgdl=1.3550e-10    cgsl=1.3550e-10  ckappa=1.0000e-01 \
     cf=0.0000e+00     elm=5.0000e+00 \
  xpart=1.0000e+00     clc=1.0000e-15     cle=6.0000e-01 \
\
   rdsw=5.7750e+03 \
   cdsc=1.2000e-02   cdscb=9.0000e-03   cdscd=1.0000e-03 \
   prwb=1.9620e-02    prwg=-1.019e-02     cit=0.0000e+00 \
tox=7.7540e-09 \
  ngate=0.0000e+00 \
    nlx=3.0770e-08 \
     xl=0.0000e+00      xw=0.0000e+00 \
     af=1.4050e+00      kf=1.8270e-26      ef=1.0000e+00 \
   noia=7.0910e+18    noib=6.0740e+04    noic=3.7790e-13 \
     rd=0.0000e+00      rs=0.0000e+00     rsh=1.2900e+02 \
   minr=1.000e-03 \
    rdc=0.0000e+00     rsc=0.0000e+00 lint=-3.275e-07 \
wint=-9.593e-07   ldif=0.000e+00    hdif=8.0000e-07 \
     xj=3.0000e-07      js=2.8000e-07 \
      n=1.0000e+00 \
  dskip=no          tlev=0           tlevc=0         \
    jsw=3.7000e-13 \
     cj=1.3600e-03    cjsw=3.5000e-10 \
     fc=0.0000e+00    fcsw=0.000e+00 \
     mj=5.4000e-01    mjsw=4.6000e-01 \
     pb=1.0200e+00    pbsw=1.0200e+00     xti=1.9730e+00
ends pmosw_3n

// ----------------------------------------------------------------------

// ----------------------------------------------------------------------
// Owner: austriamicrosystems
// HIT-Kit: Digital
// ************************ SIMULATION PARAMETERS ************************
//  ----------------------------------------------------------------------
//  format    : Spectre (Spectre Direct)
//  model     : MOS BSIM3v3
//  process   : C35
//  revision  : 1.0;
//  extracted : C18069; 28.08.2011; bse (5866)
//  doc#      : Eng-?? REV_0
//  ----------------------------------------------------------------------
//                    TYPICAL MEAN WORST NOISE CONDITION
//
//  ----------------------------------------------------------------------
//
inline subckt pmosw_4n ( d g s b )
parameters w=1.0e-6 l=1.0e-6 nrd=0.0 nrs=0.0 ad=0.0 as=0.0 pd=0.0 ps=0.0 ng=1
+ ws= w
+ ls= l
+ shk=1
+ dvthmat=(mv_pmosw_4n)*(1.03e-08/sqrt(ls*ws*ng)) dumat=(mu_pmosw_4n)*(4.89e-9/sqrt(ls*ws*ng))
//
if (modp==1)
pmosw_4n ( d g s b ) mosinsub w=ws l=ls nrd=8.0000e-07/ws nrs=8.0000e-07/ws ad=ad as=as pd=pd ps=ps m=ng
else
pmosw_4n ( d s ) resistor r=1e30
notvalid paramtest errorif=(modp==0) \
message="
***************************************************
*
* pmos is not valid in selected process option.
*
***************************************************"
model mosinsub bsim3v3 version=3.2400e+00  type=p  capmod=3.0000e+00 \
 mobmod=1.0000e+00  nqsmod=0.0000e+00  noimod=3.0000e+00 \
   vbox=1.000e+03      k1=3.3100e-01 \
     k2=0.0000e+00      k3=5.2000e+00     k3b=-1.000e+00 \
    nch=9.2400e+16 vth0=-7.440e-01+dvthmat \
   voff=-1.640e-01    dvt0=2.2000e+00    dvt1=6.3470e-01 \
   dvt2=5.3690e-02    keta=-7.600e-03 \
 pscbe1=1.0000e+30  pscbe2=1.0000e-06 \
 alpha0=1.0000e-09  alpha1=1.1750e-02   beta0=2.2870e+01 \
  dvt0w=1.0090e-01   dvt1w=7.3400e+04   dvt2w=-6.310e-03 \
     ua=4.1690e-10      ub=1.9050e-18      uc=-3.631e-11 \
u0=1.7300e+02+(1.7300e+02)*dumat \
   dsub=5.0000e-01    eta0=2.4000e-01    etab=-3.917e-03 \
nfactor=1.0000e+00 \
     em=4.1000e+07    pclm=3.5650e+00 \
  drout=5.0000e-01 \
     a0=9.0000e-01      a1=1.4440e-15      a2=5.0780e-01 \
   pvag=4.6400e+00    vsat=1.5480e+05     ags=3.8020e-01      b0=2.1920e-07      b1=0.0000e+00 \
  delta=1.0000e-02 pdiblcb=1.0000e+00 \
pdiblc1=5.6700e+00 pdiblc2=3.0670e-03 \
     w0=-1.500e-07 \
    dlc=-2.929e-08 \
dwc=-3.000e-01*l+1.5000e-07    dwb=-5.244e-09     dwg=-1.100e-08 \
     ll=3.5530e-15      lw=0.0000e+00     lwl=0.0000e+00 \
    lln=1.0000e+00     lwn=1.0000e+00      wl=-5.064e-13 \
     ww=-4.300e-14     wwl=-2.884e-21     wln=1.0000e+00 \
    wwn=1.0000e+00 \
     at=3.3000e+04     ute=-1.300e+00 \
    kt1=-4.740e-01     kt2=-5.440e-02    kt1l=-1.600e-08 \
    ua1=0.0000e+00     ub1=-3.802e-19     uc1=0.0000e+00 \
    prt=0.0000e+00 \
   cgso=9.0000e-11    cgdo=9.0000e-11    cgbo=1.7000e-08 \
   cgdl=1.3550e-10    cgsl=1.3550e-10  ckappa=1.0000e-01 \
     cf=0.0000e+00     elm=5.0000e+00 \
  xpart=1.0000e+00     clc=1.0000e-15     cle=6.0000e-01 \
\
   rdsw=5.7750e+03 \
   cdsc=1.2000e-02   cdscb=9.0000e-03   cdscd=1.0000e-03 \
   prwb=1.9620e-02    prwg=-7.244e-03     cit=0.0000e+00 \
tox=7.7540e-09 \
  ngate=0.0000e+00 \
    nlx=3.0770e-08 \
     xl=0.0000e+00      xw=0.0000e+00 \
     af=1.4050e+00      kf=1.8270e-26      ef=1.0000e+00 \
   noia=7.0910e+18    noib=6.0740e+04    noic=3.7790e-13 \
     rd=0.0000e+00      rs=0.0000e+00     rsh=1.2900e+02 \
   minr=1.000e-03 \
    rdc=0.0000e+00     rsc=0.0000e+00 lint=-2.996e-07 \
wint=-6.844e-07   ldif=0.000e+00    hdif=8.0000e-07 \
     xj=3.0000e-07      js=2.8000e-07 \
      n=1.0000e+00 \
  dskip=no          tlev=0           tlevc=0         \
    jsw=3.7000e-13 \
     cj=1.3600e-03    cjsw=3.5000e-10 \
     fc=0.0000e+00    fcsw=0.000e+00 \
     mj=5.4000e-01    mjsw=4.6000e-01 \
     pb=1.0200e+00    pbsw=1.0200e+00     xti=1.9730e+00
ends pmosw_4n

// ----------------------------------------------------------------------

// ----------------------------------------------------------------------
// Owner: austriamicrosystems
// HIT-Kit: Digital
// ************************ SIMULATION PARAMETERS ************************
//  ----------------------------------------------------------------------
//  format    : Spectre (Spectre Direct)
//  model     : MOS BSIM3v3
//  process   : C35
//  revision  : 1.0;
//  extracted : C18069; 28.08.2011; bse (5866)
//  doc#      : Eng-?? REV_0
//  ----------------------------------------------------------------------
//                    TYPICAL MEAN WORST NOISE CONDITION
//
//  ----------------------------------------------------------------------
//
inline subckt pmosmw_2n ( d g s b )
parameters w=1.0e-6 l=1.0e-6 nrd=0.0 nrs=0.0 ad=0.0 as=0.0 pd=0.0 ps=0.0 ng=1
+ ws= w
+ ls= l
+ shk=1
+ dvthmat=(mv_pmosmw_2n)*(1.5e-08/sqrt(ls*ws*ng)) dumat=(mu_pmosmw_2n)*(4.3e-9/sqrt(ls*ws*ng))
//
if (modpm==1)
pmosmw_2n ( d g s b ) mosinsub w=ws l=ls nrd=6.0000e-07/ws nrs=6.0000e-07/ws ad=ad as=as pd=pd ps=ps m=ng
else
pmosmw_2n ( d s ) resistor r=1e30
notvalid paramtest errorif=(modpm==0) \
message="
***************************************************
*
* pmosm is not valid in selected process option.
*
***************************************************"
model mosinsub bsim3v3 version=3.2400e+00  type=p  capmod=3.0000e+00 \
 mobmod=1.0000e+00  nqsmod=0.0000e+00  noimod=3.0000e+00 \
   vbox=1.000e+03      k1=5.4100e-01 \
     k2=0.0000e+00      k3=1.8000e+00     k3b=-1.000e+00 \
    nch=8.4790e+16 vth0=-1.055e+00+dvthmat \
   voff=-1.148e-01    dvt0=1.7000e+00    dvt1=4.0100e-01 \
   dvt2=2.0050e-01    keta=2.0800e-02 \
 pscbe1=1.0000e+30  pscbe2=1.0000e-06 \
 alpha0=1.0000e-07  alpha1=3.1620e+00   beta0=4.2260e+01 \
  dvt0w=2.0000e-01   dvt1w=5.0000e+05   dvt2w=-3.200e+00 \
     ua=3.1000e-09      ub=2.2000e-19      uc=-8.318e-11 \
u0=2.2900e+02+(2.2900e+02)*dumat \
   dsub=5.0000e-01    eta0=1.7900e-03    etab=-2.948e-02 \
nfactor=7.0460e-01 \
     em=4.1000e+07    pclm=4.9580e+00 \
  drout=5.0000e-01 \
     a0=1.0000e+00      a1=6.0520e-05      a2=2.2110e-01 \
   pvag=1.0000e+00    vsat=5.0470e+04     ags=1.4450e-01      b0=1.3800e-07      b1=0.0000e+00 \
  delta=1.0000e-02 pdiblcb=6.0000e-02 \
pdiblc1=2.5900e+04 pdiblc2=2.4430e-03 \
     w0=-1.800e-07 \
    dlc=-1.766e-08 \
dwc=-2.953e-01*l+1.4210e-07    dwb=-4.580e-09     dwg=-6.295e-09 \
     ll=0.0000e+00      lw=0.0000e+00     lwl=0.0000e+00 \
    lln=1.0000e+00     lwn=1.0000e+00      wl=-3.685e-12 \
     ww=-3.900e-14     wwl=-4.467e-21     wln=1.0000e+00 \
    wwn=1.0000e+00 \
     at=7.9640e+04     ute=-1.492e+00 \
    kt1=-5.480e-01     kt2=-6.000e-02    kt1l=-2.600e-08 \
    ua1=-2.630e-10     ub1=-3.311e-18     uc1=0.0000e+00 \
    prt=0.0000e+00 \
   cgso=1.0010e-10    cgdo=1.0010e-10    cgbo=8.0000e-09 \
   cgdl=1.0770e-10    cgsl=1.0770e-10  ckappa=1.3700e+00 \
     cf=0.0000e+00     elm=5.0000e+00 \
  xpart=1.0000e+00     clc=1.0000e-15     cle=6.0000e-01 \
\
   rdsw=1.0820e+04 \
   cdsc=1.2140e-03   cdscb=2.9450e-04   cdscd=0.0000e+00 \
   prwb=5.0700e-02    prwg=7.0360e-02     cit=5.2590e-05 \
tox=1.5000e-08 \
  ngate=0.0000e+00 \
    nlx=1.2500e-07 \
     xl=0.0000e+00      xw=0.0000e+00 \
     af=1.5640e+00      kf=4.8520e-26      ef=1.0000e+00 \
   noia=1.8720e+18    noib=3.4540e+04    noic=1.2460e-12 \
     rd=0.0000e+00      rs=0.0000e+00     rsh=1.3000e+02 \
   minr=1.000e-03 \
    rdc=0.0000e+00     rsc=0.0000e+00 lint=-1.646e-06 \
wint=-2.751e-06   ldif=0.000e+00    hdif=6.0000e-07 \
     xj=3.0000e-07      js=2.8000e-07 \
      n=1.0000e+00 \
  dskip=no          tlev=0           tlevc=0         \
    jsw=3.7000e-13 \
     cj=1.3600e-03    cjsw=3.5000e-10 \
     fc=0.0000e+00    fcsw=0.000e+00 \
     mj=5.4000e-01    mjsw=4.6000e-01 \
     pb=1.0200e+00    pbsw=1.0200e+00     xti=1.9700e+00
ends pmosmw_2n

// ----------------------------------------------------------------------

// ----------------------------------------------------------------------
// Owner: austriamicrosystems
// HIT-Kit: Digital
// ************************ SIMULATION PARAMETERS ************************
//  ----------------------------------------------------------------------
//  format    : Spectre (Spectre Direct)
//  model     : MOS BSIM3v3
//  process   : C35
//  revision  : 1.0;
//  extracted : C18069; 28.08.2011; bse (5866)
//  doc#      : Eng-?? REV_0
//  ----------------------------------------------------------------------
//                    TYPICAL MEAN WORST NOISE CONDITION
//
//  ----------------------------------------------------------------------
//
inline subckt pmosmw_3n ( d g s b )
parameters w=1.0e-6 l=1.0e-6 nrd=0.0 nrs=0.0 ad=0.0 as=0.0 pd=0.0 ps=0.0 ng=1
+ ws= w
+ ls= l
+ shk=1
+ dvthmat=(mv_pmosmw_3n)*(1.5e-08/sqrt(ls*ws*ng)) dumat=(mu_pmosmw_3n)*(4.3e-9/sqrt(ls*ws*ng))
//
if (modpm==1)
pmosmw_3n ( d g s b ) mosinsub w=ws l=ls nrd=6.0000e-07/ws nrs=6.0000e-07/ws ad=ad as=as pd=pd ps=ps m=ng
else
pmosmw_3n ( d s ) resistor r=1e30
notvalid paramtest errorif=(modpm==0) \
message="
***************************************************
*
* pmosm is not valid in selected process option.
*
***************************************************"
model mosinsub bsim3v3 version=3.2400e+00  type=p  capmod=3.0000e+00 \
 mobmod=1.0000e+00  nqsmod=0.0000e+00  noimod=3.0000e+00 \
   vbox=1.000e+03      k1=5.4100e-01 \
     k2=0.0000e+00      k3=1.8000e+00     k3b=-1.000e+00 \
    nch=8.4790e+16 vth0=-1.055e+00+dvthmat \
   voff=-1.148e-01    dvt0=1.7000e+00    dvt1=4.0100e-01 \
   dvt2=2.0050e-01    keta=2.0800e-02 \
 pscbe1=1.0000e+30  pscbe2=1.0000e-06 \
 alpha0=1.0000e-07  alpha1=3.1620e+00   beta0=4.2260e+01 \
  dvt0w=2.0000e-01   dvt1w=5.0000e+05   dvt2w=-3.200e+00 \
     ua=3.1000e-09      ub=2.2000e-19      uc=-1.553e-10 \
u0=2.2900e+02+(2.2900e+02)*dumat \
   dsub=5.0000e-01    eta0=1.7900e-03    etab=-2.948e-02 \
nfactor=7.0460e-01 \
     em=4.1000e+07    pclm=4.9580e+00 \
  drout=5.0000e-01 \
     a0=1.0000e+00      a1=6.0520e-05      a2=2.2110e-01 \
   pvag=-1.500e+00    vsat=4.9050e+04     ags=1.4450e-01      b0=1.3800e-07      b1=0.0000e+00 \
  delta=1.0000e-02 pdiblcb=6.0000e-02 \
pdiblc1=2.6560e+02 pdiblc2=2.6870e-03 \
     w0=-1.800e-07 \
    dlc=-1.766e-08 \
dwc=-2.953e-01*l+1.4210e-07    dwb=-4.580e-09     dwg=-6.295e-09 \
     ll=0.0000e+00      lw=0.0000e+00     lwl=0.0000e+00 \
    lln=1.0000e+00     lwn=1.0000e+00      wl=-2.315e-12 \
     ww=-3.900e-14     wwl=-4.467e-21     wln=1.0000e+00 \
    wwn=1.0000e+00 \
     at=7.9640e+04     ute=-1.492e+00 \
    kt1=-5.480e-01     kt2=-6.000e-02    kt1l=-2.600e-08 \
    ua1=-2.630e-10     ub1=-3.311e-18     uc1=0.0000e+00 \
    prt=0.0000e+00 \
   cgso=1.0010e-10    cgdo=1.0010e-10    cgbo=8.0000e-09 \
   cgdl=1.0770e-10    cgsl=1.0770e-10  ckappa=1.3700e+00 \
     cf=0.0000e+00     elm=5.0000e+00 \
  xpart=1.0000e+00     clc=1.0000e-15     cle=6.0000e-01 \
\
   rdsw=1.1340e+04 \
   cdsc=1.2140e-03   cdscb=2.9450e-04   cdscd=0.0000e+00 \
   prwb=-5.503e-02    prwg=1.5470e-02     cit=5.2590e-05 \
tox=1.5000e-08 \
  ngate=0.0000e+00 \
    nlx=1.2500e-07 \
     xl=0.0000e+00      xw=0.0000e+00 \
     af=1.5640e+00      kf=4.8520e-26      ef=1.0000e+00 \
   noia=1.8720e+18    noib=3.4540e+04    noic=1.2460e-12 \
     rd=0.0000e+00      rs=0.0000e+00     rsh=1.3000e+02 \
   minr=1.000e-03 \
    rdc=0.0000e+00     rsc=0.0000e+00 lint=-1.020e-06 \
wint=-1.770e-06   ldif=0.000e+00    hdif=6.0000e-07 \
     xj=3.0000e-07      js=2.8000e-07 \
      n=1.0000e+00 \
  dskip=no          tlev=0           tlevc=0         \
    jsw=3.7000e-13 \
     cj=1.3600e-03    cjsw=3.5000e-10 \
     fc=0.0000e+00    fcsw=0.000e+00 \
     mj=5.4000e-01    mjsw=4.6000e-01 \
     pb=1.0200e+00    pbsw=1.0200e+00     xti=1.9700e+00
ends pmosmw_3n

// ----------------------------------------------------------------------

// ----------------------------------------------------------------------
// Owner: austriamicrosystems
// HIT-Kit: Digital
// ************************ SIMULATION PARAMETERS ************************
//  ----------------------------------------------------------------------
//  format    : Spectre (Spectre Direct)
//  model     : MOS BSIM3v3
//  process   : C35
//  revision  : 1.0;
//  extracted : C18069; 28.08.2011; bse (5866)
//  doc#      : Eng-?? REV_0
//  ----------------------------------------------------------------------
//                    TYPICAL MEAN WORST NOISE CONDITION
//
//  ----------------------------------------------------------------------
//
inline subckt pmosmw_4n ( d g s b )
parameters w=1.0e-6 l=1.0e-6 nrd=0.0 nrs=0.0 ad=0.0 as=0.0 pd=0.0 ps=0.0 ng=1
+ ws= w
+ ls= l
+ shk=1
+ dvthmat=(mv_pmosmw_4n)*(1.5e-08/sqrt(ls*ws*ng)) dumat=(mu_pmosmw_4n)*(4.3e-9/sqrt(ls*ws*ng))
//
if (modpm==1)
pmosmw_4n ( d g s b ) mosinsub w=ws l=ls nrd=6.0000e-07/ws nrs=6.0000e-07/ws ad=ad as=as pd=pd ps=ps m=ng
else
pmosmw_4n ( d s ) resistor r=1e30
notvalid paramtest errorif=(modpm==0) \
message="
***************************************************
*
* pmosm is not valid in selected process option.
*
***************************************************"
model mosinsub bsim3v3 version=3.2400e+00  type=p  capmod=3.0000e+00 \
 mobmod=1.0000e+00  nqsmod=0.0000e+00  noimod=3.0000e+00 \
   vbox=1.000e+03      k1=5.4100e-01 \
     k2=0.0000e+00      k3=1.8000e+00     k3b=-1.000e+00 \
    nch=8.4790e+16 vth0=-1.055e+00+dvthmat \
   voff=-1.148e-01    dvt0=1.7000e+00    dvt1=4.0100e-01 \
   dvt2=2.0050e-01    keta=2.0800e-02 \
 pscbe1=1.0000e+30  pscbe2=1.0000e-06 \
 alpha0=1.0000e-07  alpha1=3.1620e+00   beta0=4.2260e+01 \
  dvt0w=2.0000e-01   dvt1w=5.0000e+05   dvt2w=-3.200e+00 \
     ua=3.1000e-09      ub=2.2000e-19      uc=-8.318e-11 \
u0=2.2900e+02+(2.2900e+02)*dumat \
   dsub=5.0000e-01    eta0=1.7900e-03    etab=-2.948e-02 \
nfactor=7.0460e-01 \
     em=4.1000e+07    pclm=4.9580e+00 \
  drout=5.0000e-01 \
     a0=1.0000e+00      a1=6.0520e-05      a2=2.2110e-01 \
   pvag=-1.500e+00    vsat=6.7470e+04     ags=1.4450e-01      b0=1.3800e-07      b1=0.0000e+00 \
  delta=1.0000e-02 pdiblcb=6.0000e-02 \
pdiblc1=2.8350e+01 pdiblc2=3.8950e-03 \
     w0=-1.800e-07 \
    dlc=-1.766e-08 \
dwc=-2.953e-01*l+1.4210e-07    dwb=-4.580e-09     dwg=-6.295e-09 \
     ll=0.0000e+00      lw=0.0000e+00     lwl=0.0000e+00 \
    lln=1.0000e+00     lwn=1.0000e+00      wl=-1.534e-12 \
     ww=-3.900e-14     wwl=-4.467e-21     wln=1.0000e+00 \
    wwn=1.0000e+00 \
     at=7.9640e+04     ute=-1.492e+00 \
    kt1=-5.480e-01     kt2=-6.000e-02    kt1l=-2.600e-08 \
    ua1=-2.630e-10     ub1=-3.311e-18     uc1=0.0000e+00 \
    prt=0.0000e+00 \
   cgso=1.0010e-10    cgdo=1.0010e-10    cgbo=8.0000e-09 \
   cgdl=1.0770e-10    cgsl=1.0770e-10  ckappa=1.3700e+00 \
     cf=0.0000e+00     elm=5.0000e+00 \
  xpart=1.0000e+00     clc=1.0000e-15     cle=6.0000e-01 \
\
   rdsw=6.6990e+03 \
   cdsc=1.2140e-03   cdscb=2.9450e-04   cdscd=0.0000e+00 \
   prwb=5.0700e-02    prwg=7.7360e-02     cit=5.2590e-05 \
tox=1.5000e-08 \
  ngate=0.0000e+00 \
    nlx=1.2500e-07 \
     xl=0.0000e+00      xw=0.0000e+00 \
     af=1.5640e+00      kf=4.8520e-26      ef=1.0000e+00 \
   noia=1.8720e+18    noib=3.4540e+04    noic=1.2460e-12 \
     rd=0.0000e+00      rs=0.0000e+00     rsh=1.3000e+02 \
   minr=1.000e-03 \
    rdc=0.0000e+00     rsc=0.0000e+00 lint=-7.278e-07 \
wint=-1.000e-06   ldif=0.000e+00    hdif=6.0000e-07 \
     xj=3.0000e-07      js=2.8000e-07 \
      n=1.0000e+00 \
  dskip=no          tlev=0           tlevc=0         \
    jsw=3.7000e-13 \
     cj=1.3600e-03    cjsw=3.5000e-10 \
     fc=0.0000e+00    fcsw=0.000e+00 \
     mj=5.4000e-01    mjsw=4.6000e-01 \
     pb=1.0200e+00    pbsw=1.0200e+00     xti=1.9700e+00
ends pmosmw_4n

// ----------------------------------------------------------------------

// ----------------------------------------------------------------------
// Owner: austriamicrosystems
// HIT-Kit: Digital
//************************ SIMULATION PARAMETERS ************************
// ----------------------------------------------------------------------
// format    : Spectre
// model     : MODNRF
// process   : CS ADFI
// revision  : 3.1;
// extracted : CSD C64330.04e3; 2002-09; kmo(5966)
// doc#      : ENG-188 REV_5
// ----------------------------------------------------------------------
//                  TYPICAL MEAN WORST NOISE CONDITION
// ----------------------------------------------------------------------
//
//  RF CMOS TRANSISTOR MODEL
//
//-----------------------------------------------------------------------
inline subckt modnrf ( d g s b )
parameters w=1.0e-6 l=1.0e-6 nrd=0.0 nrs=0.0 ad=0.0 as=0.0 pd=0.0 ps=0.0 ng=1
+ mmvth_modnrf=0.0 mmu0_modnrf=0.0
+ dvthmat=(mv_modnrf53+mmvth_modnrf)*(0.67e-08/sqrt(l*w*ng)) dumat=(mu_modnrf53+mmu0_modnrf)*(4.9e-9/sqrt(l*w*ng))
// //
if (modnrf==1){
// --------- Gate network ------------------------------
lg  (g 20 ) inductor l=1.000e-15
rg  (20 21 ) resistor r=((6.895e-04/w+4.758e+01 )/ng+(3.726e+05*w+2.740e+00)) isnoisy=yes
//
// --------- Drain network -----------------------------
ldrain ( d 13 ) inductor l=1.000e-15
rdrain ( 13 11 ) resistor r=(3.320e-04/(w*ng)+1.669e-01) isnoisy=yes
//
// --------- Source network -----------------------------
lsource ( s 33 ) inductor l=1.000e-15
rsource ( 33 31 ) resistor r=(3.320e-04/(w*ng)+1.669e-01) isnoisy=yes
//
// --------- Substrate network -------------------------
// Diodes are for n-type or p-type MOS transistors
//
djdb  ( 12 11 ) bulk_diode area=ad*ng perim=pd*ng
djsb  ( 32 31 ) bulk_diode area=as*ng perim=ps*ng
//
rsub1 ( 12 b ) resistor r=((0.000e+00/w+0.000e+00)/ng+(9.524e+06*w+(4.156e+01))) isnoisy=yes
rsub2 ( 32 b ) resistor r=((0.000e+00/w+0.000e+00)/ng+(9.524e+06*w+(4.156e+01))) isnoisy=yes
//
// --------- Ideal mos transistor ----------------------
modnrf ( 11 21 31 b ) mosinsub l=l w=w*ng ad=0.0 as=0.0 pd=0.0 ps=0.0 nrd=0 nrs=0
}else
modnrf ( d s ) resistor r=1e30
notvalid paramtest errorif=(modnrf==0) \
message="
***************************************************
*
* nmosrf is not valid in selected process option.
*
***************************************************"
// Intrinsic MOS transistor
model mosinsub bsim3v3 version=3.1 type=n  capmod=2.0000e+00 \
 mobmod=1.0000e+00  nqsmod=0.0000e+00  noimod=3 \
   vbox=1.000e+03      k1=6.0444e-01 \
     k2=2.9447e-03      k3=-1.715e+00     k3b=6.3250e-01 \
    nch=2.3100e+17 vth0=4.6550e-01+dvthmat \
   voff=-5.719e-02    dvt0=2.2270e+01    dvt1=1.0510e+00 \
   dvt2=3.3930e-03    keta=-6.207e-04 \
 pscbe1=2.7560e+08  pscbe2=9.6450e-06 \
 alpha0=0.0000e+00   beta0=3.0000e+01 \
  dvt0w=0.0000e+00   dvt1w=0.0000e+00   dvt2w=0.0000e+00 \
     ua=1.0000e-12      ub=4.8510e-18      uc=5.7560e-11 \
u0=6.2680e+02+(6.2680e+02)*dumat \
   dsub=5.0000e-01    eta0=3.0850e-02    etab=-3.947e-02 \
nfactor=1.1190e-01 \
     em=4.1000e+07    pclm=1.5270e+00 \
  drout=5.0000e-01 \
     a0=2.2080e+00      a1=0.0000e+00      a2=1.0000e+00 \
   pvag=0.0000e+00    vsat=7.5800e+04     ags=2.4900e-01      b0=-1.765e-08      b1=0.0000e+00 \
  delta=1.0000e-02 pdiblcb=2.5830e-01 \
pdiblc1=1.0760e-01 pdiblc2=1.4530e-03 \
     w0=1.1840e-07 \
    dlc=6.6050e-08 \
    dwc=2.6760e-08     dwb=0.0000e+00     dwg=0.0000e+00 \
     ll=0.000e+00      lw=0.000e+00     lwl=0.000e+00 \
    lln=1.000e+00     lwn=1.000e+00      wl=0.0000e+00 \
     ww=0.0000e+00     wwl=0.0000e+00     wln=1.0000e+00 \
    wwn=1.0000e+00 \
     at=3.3000e+04     ute=-1.800e+00 \
    kt1=-3.302e-01     kt2=2.2000e-02    kt1l=0.0000e+00 \
    ua1=0.0000e+00     ub1=0.0000e+00     uc1=0.0000e+00 \
    prt=0.0000e+00 \
   cgso=1.8730e-10    cgdo=1.8730e-10    cgbo=1.1000e-10 \
   cgdl=1.0680e-10    cgsl=1.0680e-10  ckappa=6.0000e-01 \
     cf=0.0000e+00     elm=5.0000e+00 \
  xpart=1.0000e+00     clc=1.0000e-15     cle=6.0000e-01 \
\
   rdsw=0.0000e+00 \
   cdsc=0.0000e+00   cdscb=0.0000e+00   cdscd=8.4480e-05 \
   prwb=0.0000e+00    prwg=0.0000e+00     cit=1.0000e-03 \
tox=7.7000e-09 \
  ngate=0.0000e+00 \
    nlx=1.9180e-07 \
     xl=0.0000e+00      xw=0.0000e+00 \
     af=1.3760e+00      kf=2.1700e-26      ef=1.0000e+00 \
   noia=1.3990e+20    noib=2.7070e+05    noic=-4.680e-12 \
     rd=0.0000e+00      rs=0.0000e+00     rsh=8.2000e+01 \
   minr=1.000e-03 \
    rdc=0.0000e+00     rsc=0.0000e+00 lint=8.2850e-09 \
wint=2.6760e-08   ldif=0.000e+00    hdif=6.0000e-07 \
     xj=3.0000e-07      js=5.1000e-07 \
      n=1.0000e+00 \
  dskip=no          tlev=0           tlevc=0         \
    jsw=0.0000e+00 \
     cj=0.0000e+00    cjsw=0.0000e+00 \
     fc=0.0000e+00    fcsw=0.000e+00 \
     mj=3.1000e-01    mjsw=1.9000e-01 \
     pb=6.9000e-01    pbsw=6.9000e-01
// Bulk Diode Model
model bulk_diode diode level=1 dskip=no \
     is=5.100e-07      isw=0.600e-12       n=1.0000000       ns=1.0000000   \
    cjo=1.580e-03       m=3.100e-01 \
    cjsw=0.000e+00       mjsw=2.011E-01 \
     fc=0.000e+00      tt=0.000e+00      vj=6.900e-01      vjsw=6.672E-01  \
     kf=0.000e+00      eg=1.11e+00     xti=2.026e+00      af=1.000e+00
ends modnrf
// ----------------------------------------------------------------------
// ----------------------------------------------------------------------
// Owner: austriamicrosystems
// HIT-Kit: Digital
//************************ SIMULATION PARAMETERS ************************
// ----------------------------------------------------------------------
// format    : Spectre
// model     : MODPRF
// process   : C/B/S 35
// revision  : 3.1;
// extracted : C35B3 B11634.L1 04PA3; 2002-09; kmo(5966)
// doc#      : ENG-188 REV_5
// ----------------------------------------------------------------------
//                  TYPICAL MEAN WORST NOISE CONDITION
// ----------------------------------------------------------------------
//
//  RF CMOS TRANSISTOR MODEL
//
//-----------------------------------------------------------------------
inline subckt modprf ( d g s b )
parameters w=1.0e-6 l=1.0e-6 nrd=0.0 nrs=0.0 ad=0.0 as=0.0 pd=0.0 ps=0.0 ng=1
+ mmvth_modprf=0.0 mmu0_modprf=0.0
+ dvthmat=(mv_modprf53+mmvth_modprf)*(1.03e-08/sqrt(l*w*ng)) dumat=(mu_modprf53+mmu0_modprf)*(7.1e-9/sqrt(l*w*ng))
// //
if (modprf==1){
// --------- Gate network ------------------------------
lg  (g 20 ) inductor l=1.000e-15
rg  (20 21 ) resistor r=((-5.800e-04/w+2.884e+02 )/ng+(-5.394e+05*w+1.596e+00)) isnoisy=yes
//
// --------- Drain network -----------------------------
ldrain ( d 13 ) inductor l=1.000e-15
rdrain ( 13 11 ) resistor r=(8.051e-04/(w*ng)+1.731e+00) isnoisy=yes
//
// --------- Source network -----------------------------
lsource ( s 33 ) inductor l=1.000e-15
rsource ( 33 31 ) resistor r=(8.051e-04/(w*ng)+1.731e+00) isnoisy=yes
//
// --------- Substrate network -------------------------
// Diodes are for n-type or p-type MOS transistors
//
djdb  ( 11 12 ) bulk_diode area=ad*ng perim=pd*ng
djsb  ( 31 32 ) bulk_diode area=as*ng perim=ps*ng
//
rsub1 ( 12 b ) resistor r=((1.064e-04/w+1.682e+02)/ng+(1.724e+06*w+(-2.292e+00))) isnoisy=yes
rsub2 ( 32 b ) resistor r=((1.064e-04/w+1.682e+02)/ng+(1.724e+06*w+(-2.292e+00))) isnoisy=yes
//
// --------- Ideal mos transistor ----------------------
modprf ( 11 21 31 b ) mosinsub l=l w=w*ng ad=0.0 as=0.0 pd=0.0 ps=0.0 nrd=0 nrs=0
}else
modprf ( d s ) resistor r=1e30
notvalid paramtest errorif=(modprf==0) \
message="
***************************************************
*
* pmosrf is not valid in selected process option.
*
***************************************************"
// Intrinsic MOS transistor
model mosinsub bsim3v3 version=3.1 type=p  capmod=2.0000e+00 \
 mobmod=1.0000e+00  nqsmod=0.0000e+00  noimod=3 \
   vbox=1.000e+03      k1=1.3514e-02 \
     k2=1.2501e-01      k3=1.1030e+01     k3b=-7.580e-01 \
    nch=1.4580e+17 vth0=-7.359e-01+dvthmat \
   voff=-1.170e-01    dvt0=1.6500e+00    dvt1=3.8680e-01 \
   dvt2=1.6590e-02    keta=-1.440e-02 \
 pscbe1=5.0000e+09  pscbe2=1.0000e-04 \
 alpha0=0.0000e+00   beta0=3.0000e+01 \
  dvt0w=1.8790e-01   dvt1w=7.3350e+04   dvt2w=-6.312e-03 \
     ua=5.3940e-10      ub=3.9760e-19      uc=1.0000e-20 \
u0=1.3230e+02+(1.3230e+02)*dumat \
   dsub=5.0000e-01    eta0=2.4800e-01    etab=-3.917e-03 \
nfactor=1.2140e+00 \
     em=4.1000e+07    pclm=1.8290e+00 \
  drout=5.0000e-01 \
     a0=5.8500e-01      a1=0.0000e+00      a2=1.0000e+00 \
   pvag=0.0000e+00    vsat=4.8240e+04     ags=2.4680e-01      b0=8.8320e-08      b1=0.0000e+00 \
  delta=1.0000e-02 pdiblcb=1.0000e+00 \
pdiblc1=1.0000e-04 pdiblc2=1.0000e-20 \
     w0=1.0000e-10 \
    dlc=5.6730e-08 \
    dwc=3.4490e-08     dwb=0.0000e+00     dwg=0.0000e+00 \
     ll=0.000e+00      lw=0.000e+00     lwl=0.000e+00 \
    lln=1.000e+00     lwn=1.000e+00      wl=0.0000e+00 \
     ww=1.8940e-16     wwl=-1.981e-21     wln=1.0000e+00 \
    wwn=1.0400e+00 \
     at=3.3000e+04     ute=-1.300e+00 \
    kt1=-5.403e-01     kt2=2.2000e-02    kt1l=0.0000e+00 \
    ua1=0.0000e+00     ub1=0.0000e+00     uc1=0.0000e+00 \
    prt=0.0000e+00 \
   cgso=1.0000e-12    cgdo=1.0000e-12    cgbo=1.1000e-10 \
   cgdl=2.5880e-10    cgsl=2.5880e-10  ckappa=6.0000e-01 \
     cf=0.0000e+00     elm=5.0000e+00 \
  xpart=1.0000e+00     clc=1.0000e-15     cle=6.0000e-01 \
\
   rdsw=0.0000e+00 \
   cdsc=2.5890e-03   cdscb=2.9430e-04   cdscd=4.3700e-04 \
   prwb=-9.731e-02    prwg=1.4770e-01     cit=0.0000e+00 \
tox=7.7540e-09 \
  ngate=0.0000e+00 \
    nlx=1.7700e-07 \
     xl=0.0000e+00      xw=0.0000e+00 \
     af=1.4050e+00      kf=1.1910e-26      ef=1.0000e+00 \
   noia=7.0910e+18    noib=6.0740e+04    noic=3.7790e-13 \
     rd=0.0000e+00      rs=0.0000e+00     rsh=1.2900e+02 \
   minr=1.000e-03 \
    rdc=0.0000e+00     rsc=0.0000e+00 lint=-1.164e-08 \
wint=3.4490e-08   ldif=0.000e+00    hdif=8.0000e-07 \
     xj=3.0000e-07      js=2.8000e-07 \
      n=1.0000e+00 \
  dskip=no          tlev=0           tlevc=0         \
    jsw=3.7000e-13 \
     cj=0.0000e+00    cjsw=0.0000e+00 \
     fc=0.0000e+00    fcsw=0.000e+00 \
     mj=5.6000e-01    mjsw=4.3000e-01 \
     pb=1.0200e+00    pbsw=1.0200e+00
// Bulk Diode Model
model bulk_diode diode level=1 dskip=no \
     is=2.800e-07      isw=3.700e-13       n=1.0000000       ns=1.0000000   \
    cjo=1.526e-03       m=1.176e-01 \
    cjsw=0.000e+00       mjsw=4.300e-01 \
     fc=0.000e+00      tt=0.000e+00      vj=1.020e+00      vjsw=1.020e+00  \
     kf=0.000e+00      eg=1.11e+00     xti=1.973e+00      af=1.000e+00
ends modprf
// ----------------------------------------------------------------------
//-------------- END OF Section ------------------
endsection
section cmosmc
//
// ----------------------------------------------------------------------
// Owner: austriamicrosystems
// HIT-Kit: Digital
// ************************ SIMULATION PARAMETERS ************************
//  ----------------------------------------------------------------------
//  format    : Spectre (Spectre Direct)
//  model     : MOS BSIM3v3
//  process   : C35
//  revision  : 4.0;
//  extracted : B10866 ; 2002-12; ese(5487)
//  doc#      : ENG-182 REV_6
//  ----------------------------------------------------------------------
//                        MONTE-CARLO SIMULATION
//
//  ----------------------------------------------------------------------
//
inline subckt modn ( d g s b )
parameters w=1.0e-6 l=1.0e-6 nrd=0.0 nrs=0.0 ad=0.0 as=0.0 pd=0.0 ps=0.0 ng=1
+ ws= w
+ ls= l
+ shk=1
+ dvthmat=(mv_modn)*(0.67e-08/sqrt(ls*ws*ng)) dumat=(mu_modn)*(4.9e-9/sqrt(ls*ws*ng))
+ dkf=2.1700e-26*((-1.631e+00)*exp((-4.000e-03)*ls*ws*1e12)+(-5.060e-01))
+ dnoia=noia1*((1.538e+00)*exp((-1.730e-01)*ls*ws*1e12)+(1.747e+00))
//
if (modn==1)
modn ( d g s b ) mosinsub w=ws l=ls nrd=nrd nrs=nrs ad=ad as=as pd=pd ps=ps m=ng
else
modn ( d s ) resistor r=1e30
notvalid paramtest errorif=(modn==0) \
message="
***************************************************
*
* nmos is not valid in selected process option.
*
***************************************************"
model mosinsub bsim3v3 version=3.2400e+00  type=n  capmod=2.0000e+00 \
 mobmod=1.0000e+00  nqsmod=0.0000e+00  noimod=3 \
   vbox=1.000e+03      k1=4.9550e-01 \
     k2=3.5770e-02      k3=-1.136e+00     k3b=-4.399e-01 \
    nch=npeak1 vth0=4.9790e-01+delvton+dvthmat \
   voff=-8.925e-02    dvt0=5.0000e+01    dvt1=1.0390e+00 \
   dvt2=-8.375e-03    keta=2.0320e-02 \
 pscbe1=1.0000e+30  pscbe2=1.0000e-06 \
 alpha0=2.6000e-06  alpha1=5.0000e+00   beta0=2.1000e+01 \
  dvt0w=1.0890e-01   dvt1w=6.6710e+04   dvt2w=-1.352e-02 \
     ua=4.7050e-12      ub=2.1370e-18      uc=1.0000e-20 \
u0=4.7580e+02+deluon+(4.7580e+02+deluon)*dumat \
   dsub=5.0000e-01    eta0=1.4150e-02    etab=-1.221e-01 \
nfactor=4.1360e-01 \
     em=4.1000e+07    pclm=6.9480e-01 \
  drout=5.0000e-01 \
     a0=2.5410e+00      a1=0.0000e+00      a2=1.0000e+00 \
   pvag=0.0000e+00    vsat=1.3380e+05     ags=2.4080e-01      b0=4.3010e-09      b1=0.0000e+00 \
  delta=1.4420e-02 pdiblcb=3.2220e-01 \
pdiblc1=3.5710e-01 pdiblc2=2.0650e-03 \
     w0=2.6730e-07 \
    dlc=3.0000e-08 \
    dwc=9.4030e-08     dwb=0.0000e+00     dwg=0.0000e+00 \
     ll=0.000e+00      lw=0.000e+00     lwl=0.000e+00 \
    lln=1.000e+00     lwn=1.000e+00      wl=0.0000e+00 \
     ww=-1.297e-14     wwl=-9.411e-21     wln=1.0000e+00 \
     wr=1.0000e+00     wwn=1.0000e+00 \
     at=3.3000e+04     ute=-1.800e+00 \
    kt1=-3.302e-01     kt2=2.2000e-02    kt1l=0.0000e+00 \
    ua1=0.0000e+00     ub1=0.0000e+00     uc1=0.0000e+00 \
    prt=0.0000e+00 \
   cgso=cgsdon        cgdo=cgsdon        cgbo=cgbon      \
   cgdl=1.3100e-10    cgsl=1.3100e-10  ckappa=6.0000e-01 \
     cf=0.0000e+00     elm=5.0000e+00 \
  xpart=1.0000e+00     clc=1.0000e-15     cle=6.0000e-01 \
   noff=1.0000e+00  voffcv=0.0000e+00 \
   rdsw=3.4490e+02 \
   cdsc=0.0000e+00   cdscb=1.5000e-03   cdscd=1.0000e-03 \
   prwb=-2.416e-01    prwg=0.0000e+00     cit=4.4410e-04 \
tox=7.5750e-09+deltgox \
  ngate=0.0000e+00 \
    nlx=1.8880e-07 \
     xl=0.0000e+00+dell      xw=0.0000e+00+delw \
     af=1.5070e+00  kf=min(exp(ln(2.170e-26)+dkf),3.396e-26)     ef=1.0000e+00 \
 noia=min(exp(ln(1.121e+19)+dnoia),1.399e+20) noib=min(exp(noib1),2.707e+05)   noic=-5.892e-13 \
     rd=0.0000e+00      rs=0.0000e+00     rsh=7.0000e+01+drdiffn \
   minr=1.000e-03 \
    rdc=0.0000e+00     rsc=0.0000e+00 lint=-5.005e-08 \
wint=9.4030e-08   ldif=0.000e+00    hdif=8.0000e-07 \
     xj=3.0000e-07      js=5.1000e-07 \
      n=1.0000e+00 \
  dskip=no          tlev=0           tlevc=0         \
    jsw=6.0000e-13 \
     cj=cj1    cjsw=cjsw1 \
     fc=0.0000e+00    fcsw=0.000e+00 \
     mj=3.4000e-01    mjsw=2.3000e-01 \
     pb=6.9000e-01    pbsw=6.9000e-01     xti=2.0260e+00
ends modn

// ----------------------------------------------------------------------
// ----------------------------------------------------------------------
// Owner: austriamicrosystems
// HIT-Kit: Digital
// ************************ SIMULATION PARAMETERS ************************
//  ----------------------------------------------------------------------
//  format    : Spectre (Spectre Direct)
//  model     : MOS BSIM3v3
//  process   : C35
//  revision  : 4.1;
//  extracted : B11004 ; 2002-12; ese(5487)
//  doc#      : ENG-182 REV_6
//  ----------------------------------------------------------------------
//                        MONTE-CARLO SIMULATION
//
//  ----------------------------------------------------------------------
//
inline subckt modnm ( d g s b )
parameters w=1.0e-6 l=1.0e-6 nrd=0.0 nrs=0.0 ad=0.0 as=0.0 pd=0.0 ps=0.0 ng=1
+ ws= w
+ ls= l
+ shk=1
+ dvthmat=(mv_modnm)*(1.03e-08/sqrt(ls*ws*ng)) dumat=(mu_modnm)*(3.5e-9/sqrt(ls*ws*ng))
+ dkf=9.1800e-26*((-1.631e+00)*exp((-4.000e-03)*ls*ws*1e12)+(-5.060e-01))
+ dnoia=noia2*((2.290e+00)*exp((-9.000e-03)*ls*ws*1e12)+(5.220e-01))
//
if (modnm==1)
modnm ( d g s b ) mosinsub w=ws l=ls nrd=nrd nrs=nrs ad=ad as=as pd=pd ps=ps m=ng
else
modnm ( d s ) resistor r=1e30
notvalid paramtest errorif=(modnm==0) \
message="
***************************************************
*
* nmosm is not valid in selected process option.
*
***************************************************"
model mosinsub bsim3v3 version=3.2400e+00  type=n  capmod=2.0000e+00 \
 mobmod=1.0000e+00  nqsmod=0.0000e+00  noimod=3 \
   vbox=1.000e+03      k1=7.2143e-01 \
     k2=1.1703e-01      k3=-3.776e+00     k3b=-7.691e-02 \
    nch=npeak2 vth0=7.5250e-01+delvtonm+dvthmat \
   voff=-8.295e-02    dvt0=3.0000e+01    dvt1=1.5280e+00 \
   dvt2=2.5290e-02    keta=3.5850e-02 \
 pscbe1=1.0000e+30  pscbe2=1.0000e-06 \
 alpha0=7.7410e-09  alpha1=3.9830e-01   beta0=2.0700e+01 \
  dvt0w=-5.000e+00   dvt1w=2.5780e+06   dvt2w=5.1050e-02 \
     ua=4.7080e-10      ub=1.4700e-18      uc=-4.342e-11 \
u0=5.6430e+02+deluonm+(5.6430e+02+deluonm)*dumat \
   dsub=5.0000e-01    eta0=3.7950e-02    etab=-7.653e-04 \
nfactor=8.5730e-01 \
     em=4.1000e+07    pclm=2.1250e-01 \
  drout=5.0000e-01 \
     a0=2.0640e+00      a1=0.0000e+00      a2=1.0000e+00 \
   pvag=0.0000e+00    vsat=1.0780e+05     ags=1.0790e-01      b0=-1.493e-07      b1=0.0000e+00 \
  delta=1.0000e-02 pdiblcb=5.1860e-01 \
pdiblc1=1.0000e-04 pdiblc2=5.4580e-04 \
     w0=1.6170e-07 \
    dlc=1.0000e-07 \
    dwc=1.6230e-07     dwb=0.0000e+00     dwg=0.0000e+00 \
     ll=0.000e+00      lw=0.000e+00     lwl=0.000e+00 \
    lln=1.000e+00     lwn=1.000e+00      wl=0.0000e+00 \
     ww=-5.117e-14     wwl=-5.704e-21     wln=1.0000e+00 \
     wr=1.0000e+00     wwn=1.0000e+00 \
     at=3.3000e+04     ute=-1.760e+00 \
    kt1=-4.502e-01     kt2=2.2000e-02    kt1l=0.0000e+00 \
    ua1=0.0000e+00     ub1=0.0000e+00     uc1=0.0000e+00 \
    prt=0.0000e+00 \
   cgso=cgsdonm        cgdo=cgsdonm        cgbo=cgbonm      \
   cgdl=2.2700e-10    cgsl=2.2700e-10  ckappa=6.0000e-01 \
     cf=0.0000e+00     elm=5.0000e+00 \
  xpart=1.0000e+00     clc=1.0000e-15     cle=6.0000e-01 \
   noff=1.0000e+00  voffcv=0.0000e+00 \
   rdsw=1.3900e+03 \
   cdsc=0.0000e+00   cdscb=-1.500e-03   cdscd=0.0000e+00 \
   prwb=-6.740e-02    prwg=0.0000e+00     cit=0.0000e+00 \
tox=1.5160e-08+deltgoxm \
  ngate=0.0000e+00 \
    nlx=2.2830e-07 \
     xl=0.0000e+00+dellm      xw=0.0000e+00+delwm \
     af=1.6290e+00  kf=min(exp(ln(9.180e-26)+dkf),3.446e-26)     ef=1.0000e+00 \
 noia=min(exp(ln(2.245e+19)+dnoia),1.702e+20) noib=min(exp(noib2),5.463e+05)   noic=-1.680e-12 \
     rd=0.0000e+00      rs=0.0000e+00     rsh=7.9000e+01+drdiffn \
   minr=1.000e-03 \
    rdc=0.0000e+00     rsc=0.0000e+00 lint=1.2250e-07 \
wint=1.6230e-07   ldif=0.000e+00    hdif=6.0000e-07 \
     xj=3.0000e-07      js=5.1000e-07 \
      n=1.0000e+00 \
  dskip=no          tlev=0           tlevc=0         \
    jsw=6.0000e-13 \
     cj=cj2    cjsw=cjsw2 \
     fc=0.0000e+00    fcsw=0.000e+00 \
     mj=3.4000e-01    mjsw=2.3000e-01 \
     pb=6.9000e-01    pbsw=6.9000e-01     xti=2.0260e+00
ends modnm

// ----------------------------------------------------------------------

// ----------------------------------------------------------------------
// Owner: austriamicrosystems
// HIT-Kit: Digital
// ************************ SIMULATION PARAMETERS ************************
//  ----------------------------------------------------------------------
//  format    : Spectre (Spectre Direct)
//  model     : MOS BSIM3v3
//  process   : C35
//  revision  : 5.0;
//  extracted : B27167L1W5C45; 15-04-2007; bse (5866)
//  doc#      : Eng-182 REV_6
//  ----------------------------------------------------------------------
//                        MONTE-CARLO SIMULATION
//
//  ----------------------------------------------------------------------
//
inline subckt modnl ( d g s b )
parameters w=1.0e-6 l=1.0e-6 nrd=0.0 nrs=0.0 ad=0.0 as=0.0 pd=0.0 ps=0.0 ng=1
+ ws= w
+ ls= l
+ shk=1
+ dvthmat=(mv_modnl)*(0.67e-08/sqrt(ls*ws*ng)) dumat=(mu_modnl)*(4.9e-9/sqrt(ls*ws*ng))
+ dkf=6.1730e-26*((-9.420e-01)*exp((-5.000e-03)*ls*ws*1e12)+(-3.610e-01))
+ dnoia=noia3*((1.235e+00)*exp((-2.240e-01)*ls*ws*1e12)+(1.595e+00))
//
if (modnl==1)
modnl ( d g s b ) mosinsub w=ws l=ls nrd=8.0000e-07/ws nrs=8.0000e-07/ws ad=ad as=as pd=pd ps=ps m=ng
else
modnl ( d s ) resistor r=1e30
notvalid paramtest errorif=(modnl==0) \
message="
***************************************************
*
* nmosl is not valid in selected process option.
*
***************************************************"
model mosinsub bsim3v3 version=3.2400e+00  type=n  capmod=2.0000e+00 \
 mobmod=1.0000e+00  nqsmod=0.0000e+00  noimod=3.0000e+00 \
   vbox=1.000e+03      k1=5.4000e-01 \
     k2=0.0000e+00      k3=7.6040e+00     k3b=0.0000e+00 \
    nch=npeak3 vth0=4.2200e-01+delvtontlv+dvthmat \
   voff=-8.000e-02    dvt0=1.2570e+01    dvt1=8.1290e-01 \
   dvt2=2.2200e-15    keta=-2.800e-03 \
 pscbe1=1.0000e+30  pscbe2=1.0000e-06 \
 alpha0=1.9000e-06  alpha1=1.0000e+00   beta0=2.0000e+01 \
  dvt0w=0.0000e+00   dvt1w=1.6970e+06   dvt2w=2.5060e-01 \
     ua=1.0000e-12      ub=2.1880e-18      uc=7.2440e-11 \
u0=4.4700e+02+deluontlv+(4.4700e+02+deluontlv)*dumat \
   dsub=5.0000e-01    eta0=5.1580e-02    etab=-6.600e-02 \
nfactor=1.0000e+00 \
     em=4.1000e+07    pclm=1.2650e+00 \
  drout=5.0000e-01 \
     a0=1.7080e+00      a1=0.0000e+00      a2=1.0000e+00 \
   pvag=3.1500e-01    vsat=9.4190e+04     ags=3.1620e-01      b0=2.6240e-08      b1=0.0000e+00 \
  delta=1.0000e-03 pdiblcb=3.6000e-01 \
pdiblc1=1.2970e-01 pdiblc2=1.9500e-03 \
     w0=2.5000e-06 \
    dlc=3.0000e-08 \
    dwc=9.5120e-08     dwb=0.0000e+00     dwg=-7.686e-09 \
     ll=6.3200e-15      lw=0.0000e+00     lwl=0.0000e+00 \
    lln=1.0000e+00     lwn=1.0000e+00      wl=0.0000e+00 \
     ww=-2.855e-14     wwl=-4.365e-21     wln=1.0000e+00 \
     wr=1.0000e+00     wwn=1.0000e+00 \
     at=1.0000e+04     ute=-1.700e+00 \
    kt1=-3.400e-01     kt2=-4.840e-02    kt1l=0.0000e+00 \
    ua1=0.0000e+00     ub1=0.0000e+00     uc1=0.0000e+00 \
    prt=0.0000e+00 \
   cgso=cgsdonlv        cgdo=cgsdonlv        cgbo=cgbonlv      \
   cgdl=3.5000e-10    cgsl=3.5000e-10  ckappa=1.7010e+00 \
     cf=0.0000e+00     elm=5.0000e+00 \
  xpart=1.0000e+00     clc=1.0000e-15     cle=6.0000e-01 \
\
   rdsw=4.4670e+02 \
   cdsc=1.0000e-09   cdscb=0.0000e+00   cdscd=0.0000e+00 \
   prwb=0.0000e+00    prwg=1.9050e-02     cit=0.0000e+00 \
tox=7.6700e-09+deltgoxtlv \
  ngate=0.0000e+00 \
    nlx=1.4300e-07 \
     xl=0.0000e+00+delltlv      xw=0.0000e+00+delwtlv \
     af=1.6120e+00  kf=min(exp(ln(6.173e-26)+dkf),6.986e-26)     ef=1.0000e+00 \
 noia=min(exp(ln(1.004e+19)+dnoia),9.864e+19) noib=min(exp(noib3),1.702e+05)   noic=-1.274e-12 \
     rd=0.0000e+00      rs=0.0000e+00     rsh=7.5000e+01+drdiffn \
   minr=1.000e-03 \
    rdc=0.0000e+00     rsc=0.0000e+00 lint=-6.902e-09 \
wint=9.5120e-08   ldif=0.000e+00    hdif=8.0000e-07 \
     xj=3.0000e-07      js=5.1000e-07 \
      n=1.0000e+00 \
  dskip=no          tlev=0           tlevc=0         \
    jsw=6.0000e-13 \
     cj=cj3    cjsw=cjsw3 \
     fc=0.0000e+00    fcsw=0.000e+00 \
     mj=3.4000e-01    mjsw=2.3000e-01 \
     pb=6.9000e-01    pbsw=6.9000e-01     xti=2.0300e+00
ends modnl

// ----------------------------------------------------------------------

// ----------------------------------------------------------------------
// Owner: austriamicrosystems
// HIT-Kit: Digital
// ************************ SIMULATION PARAMETERS ************************
//  ----------------------------------------------------------------------
//  format    : Spectre (Spectre Direct)
//  model     : MOS BSIM3v3
//  process   : C35
//  revision  : 5.0;
//  extracted : B27167L1W5C45; 15-04-2007; bse (5866)
//  doc#      : Eng-182 REV_6
//  ----------------------------------------------------------------------
//                        MONTE-CARLO SIMULATION
//
//  ----------------------------------------------------------------------
//
inline subckt modnml ( d g s b )
parameters w=1.0e-6 l=1.0e-6 nrd=0.0 nrs=0.0 ad=0.0 as=0.0 pd=0.0 ps=0.0 ng=1
+ ws= w
+ ls= l
+ shk=1
+ dvthmat=(mv_modnml)*(0.95e-08/sqrt(ls*ws*ng)) dumat=(mu_modnml)*(3.5e-9/sqrt(ls*ws*ng))
+ dkf=5.7540e-26*((-1.401e+00)*exp((-2.100e-02)*ls*ws*1e12)+(-3.960e-01))
+ dnoia=noia4*((2.050e+00)*exp((-1.400e-01)*ls*ws*1e12)+(1.526e+00))
//
if (modnml==1)
modnml ( d g s b ) mosinsub w=ws l=ls nrd=6.0000e-07/ws nrs=6.0000e-07/ws ad=ad as=as pd=pd ps=ps m=ng
else
modnml ( d s ) resistor r=1e30
notvalid paramtest errorif=(modnml==0) \
message="
***************************************************
*
* nmosml is not valid in selected process option.
*
***************************************************"
model mosinsub bsim3v3 version=3.2400e+00  type=n  capmod=2.0000e+00 \
 mobmod=1.0000e+00  nqsmod=0.0000e+00  noimod=3.0000e+00 \
   vbox=1.000e+03      k1=9.8000e-01 \
     k2=0.0000e+00      k3=-1.456e+00     k3b=-7.244e-01 \
    nch=npeak4 vth0=5.7940e-01+delvtonmlv+dvthmat \
   voff=-8.684e-02    dvt0=1.6010e+01    dvt1=1.0610e+00 \
   dvt2=4.5970e-02    keta=1.9180e-02 \
 pscbe1=1.0000e+30  pscbe2=1.0000e-06 \
 alpha0=1.6220e-08  alpha1=1.3800e-01   beta0=2.1000e+01 \
  dvt0w=0.0000e+00   dvt1w=3.0990e+06   dvt2w=4.5170e-02 \
     ua=1.0000e-12      ub=2.2910e-18      uc=6.9180e-11 \
u0=4.9000e+02+deluonmlv+(4.9000e+02+deluonmlv)*dumat \
   dsub=5.0000e-01    eta0=5.1290e-02    etab=-5.126e-03 \
nfactor=9.6050e-01 \
     em=4.1000e+07    pclm=1.1380e+00 \
  drout=5.0000e-01 \
     a0=1.0460e+00      a1=0.0000e+00      a2=1.0000e+00 \
   pvag=5.0000e-02    vsat=8.4420e+04     ags=1.2000e-01      b0=0.0000e+00      b1=0.0000e+00 \
  delta=1.8640e-03 pdiblcb=9.7980e-01 \
pdiblc1=6.1030e-06 pdiblc2=7.2440e-04 \
     w0=3.3160e-08 \
    dlc=1.0000e-07 \
    dwc=1.1660e-07     dwb=5.8200e-09     dwg=-1.000e-09 \
     ll=-9.793e-15      lw=0.0000e+00     lwl=0.0000e+00 \
    lln=1.0000e+00     lwn=1.0000e+00      wl=0.0000e+00 \
     ww=-4.017e-14     wwl=-1.380e-21     wln=1.0000e+00 \
     wr=1.0000e+00     wwn=1.0000e+00 \
     at=4.3550e+04     ute=-1.720e+00 \
    kt1=-4.500e-01     kt2=-6.560e-02    kt1l=0.0000e+00 \
    ua1=2.7540e-10     ub1=0.0000e+00     uc1=0.0000e+00 \
    prt=2.0000e+02 \
   cgso=cgsdonmlv        cgdo=cgsdonmlv        cgbo=cgbonmlv      \
   cgdl=4.3400e-10    cgsl=4.3400e-10  ckappa=1.9040e+00 \
     cf=0.0000e+00     elm=5.0000e+00 \
  xpart=1.0000e+00     clc=1.0000e-15     cle=6.0000e-01 \
\
   rdsw=1.1940e+03 \
   cdsc=2.4000e-04   cdscb=-7.468e-04   cdscd=0.0000e+00 \
   prwb=5.2110e-02    prwg=-5.443e-02     cit=0.0000e+00 \
tox=1.5700e-08+deltgoxmlv \
  ngate=1.0000e+00 \
    nlx=2.3690e-07 \
     xl=0.0000e+00+dellmlv      xw=0.0000e+00+delwmlv \
     af=1.5880e+00  kf=min(exp(ln(5.754e-26)+dkf),3.770e-26)     ef=1.0000e+00 \
 noia=min(exp(ln(1.594e+19)+dnoia),1.536e+20) noib=min(exp(noib4),3.584e+05)   noic=-3.506e-12 \
     rd=0.0000e+00      rs=0.0000e+00     rsh=7.9000e+01+drdiffn \
   minr=1.000e-03 \
    rdc=0.0000e+00     rsc=0.0000e+00 lint=1.1900e-07 \
wint=1.1660e-07   ldif=0.000e+00    hdif=6.0000e-07 \
     xj=3.0000e-07      js=5.1000e-07 \
      n=1.0000e+00 \
  dskip=no          tlev=0           tlevc=0         \
    jsw=6.0000e-13 \
     cj=cj4    cjsw=cjsw4 \
     fc=0.0000e+00    fcsw=0.000e+00 \
     mj=3.4000e-01    mjsw=2.3000e-01 \
     pb=6.9000e-01    pbsw=6.9000e-01     xti=2.0300e+00
ends modnml

// ----------------------------------------------------------------------
// ----------------------------------------------------------------------
// Owner: austriamicrosystems
// HIT-Kit: Digital
// ************************ SIMULATION PARAMETERS ************************
//  ----------------------------------------------------------------------
//  format    : Spectre (Spectre Direct)
//  model     : MOS BSIM3v3
//  process   : C35
//  revision  : 4.1;
//  extracted : C64685 ; 2002-12; ese(5487)
//  doc#      : ENG-182 REV_6
//  ----------------------------------------------------------------------
//                        MONTE-CARLO SIMULATION
//
//  ----------------------------------------------------------------------
//
inline subckt modpm ( d g s b )
parameters w=1.0e-6 l=1.0e-6 nrd=0.0 nrs=0.0 ad=0.0 as=0.0 pd=0.0 ps=0.0 ng=1
+ ws= w
+ ls= l
+ shk=1
+ dvthmat=(mv_modpm)*(1.5e-08/sqrt(ls*ws*ng)) dumat=(mu_modpm)*(7.1e-9/sqrt(ls*ws*ng))
+ dkf=3.6250e-26*((-1.163e+00)*exp((-0.024e+00)*ls*ws*1e12)+(-0.247e+00))
+ dnoia=noia5*((1.848e+00)*exp((-1.400e-01)*ls*ws*1e12)+(1.376e+00))
//
if (modpm==1)
modpm ( d g s b ) mosinsub w=ws l=ls nrd=nrd nrs=nrs ad=ad as=as pd=pd ps=ps m=ng
else
modpm ( d s ) resistor r=1e30
notvalid paramtest errorif=(modpm==0) \
message="
***************************************************
*
* pmosm is not valid in selected process option.
*
***************************************************"
model mosinsub bsim3v3 version=3.2400e+00  type=p  capmod=2.0000e+00 \
 mobmod=1.0000e+00  nqsmod=0.0000e+00  noimod=3 \
   vbox=1.000e+03      k1=5.5751e-01 \
     k2=4.3858e-02      k3=8.3170e+00     k3b=-1.479e+00 \
    nch=npeak5 vth0=-1.011e+00+delvtopm+dvthmat \
   voff=-1.148e-01    dvt0=5.3990e-01    dvt1=4.1120e-01 \
   dvt2=-9.479e-02    keta=3.0100e-02 \
 pscbe1=1.0000e+30  pscbe2=1.0000e-06 \
 alpha0=2.7100e-07  alpha1=1.9100e+00   beta0=3.4770e+01 \
  dvt0w=8.0990e-01   dvt1w=1.4800e+05   dvt2w=4.4040e-02 \
     ua=1.8000e-12      ub=2.2180e-18      uc=-7.278e-11 \
u0=1.3730e+02+deluopm+(1.3730e+02+deluopm)*dumat \
   dsub=5.0000e-01    eta0=9.7360e-02    etab=-2.948e-02 \
nfactor=7.0460e-01 \
     em=4.1000e+07    pclm=4.3950e+00 \
  drout=5.0000e-01 \
     a0=1.3860e+00      a1=0.0000e+00      a2=1.0000e+00 \
   pvag=0.0000e+00    vsat=1.4360e+05     ags=1.3640e-01      b0=1.9910e-08      b1=0.0000e+00 \
  delta=1.0000e-02 pdiblcb=1.0000e+00 \
pdiblc1=2.0370e-02 pdiblc2=1.0000e-20 \
     w0=1.0000e-10 \
    dlc=2.5000e-08 \
    dwc=6.2030e-08     dwb=0.0000e+00     dwg=0.0000e+00 \
     ll=0.000e+00      lw=0.000e+00     lwl=0.000e+00 \
    lln=1.000e+00     lwn=1.000e+00      wl=0.0000e+00 \
     ww=-9.750e-16     wwl=-1.787e-21     wln=1.0000e+00 \
     wr=1.0000e+00     wwn=1.0400e+00 \
     at=3.3000e+04     ute=-1.300e+00 \
    kt1=-6.003e-01     kt2=2.2000e-02    kt1l=0.0000e+00 \
    ua1=0.0000e+00     ub1=0.0000e+00     uc1=0.0000e+00 \
    prt=0.0000e+00 \
   cgso=cgsdopm        cgdo=cgsdopm        cgbo=cgbopm      \
   cgdl=6.0000e-11    cgsl=6.0000e-11  ckappa=6.0000e-01 \
     cf=0.0000e+00     elm=5.0000e+00 \
  xpart=1.0000e+00     clc=1.0000e-15     cle=6.0000e-01 \
   noff=1.0000e+00  voffcv=0.0000e+00 \
   rdsw=1.6230e+03 \
   cdsc=1.2140e-03   cdscb=2.9450e-04   cdscd=0.0000e+00 \
   prwb=-4.521e-01    prwg=0.0000e+00     cit=5.2590e-05 \
tox=1.4500e-08+deltgoxm \
  ngate=0.0000e+00 \
    nlx=2.2310e-07 \
     xl=0.0000e+00+dellm      xw=0.0000e+00+delwm \
     af=1.6380e+00  kf=min(exp(ln(3.625e-26)+dkf),4.852e-26)     ef=1.0000e+00 \
 noia=min(exp(ln(5.846e+17)+dnoia),1.872e+18) noib=min(exp(noib5),3.454e+04)   noic=7.7590e-13 \
     rd=0.0000e+00      rs=0.0000e+00     rsh=1.3000e+02+drdiffp \
   minr=1.000e-03 \
    rdc=0.0000e+00     rsc=0.0000e+00 lint=-8.504e-08 \
wint=6.2030e-08   ldif=0.000e+00    hdif=6.0000e-07 \
     xj=3.0000e-07      js=2.8000e-07 \
      n=1.0000e+00 \
  dskip=no          tlev=0           tlevc=0         \
    jsw=3.7000e-13 \
     cj=cj5    cjsw=cjsw5 \
     fc=0.0000e+00    fcsw=0.000e+00 \
     mj=5.4000e-01    mjsw=4.6000e-01 \
     pb=1.0200e+00    pbsw=1.0200e+00     xti=1.9700e+00
ends modpm

// ----------------------------------------------------------------------

// ----------------------------------------------------------------------
// Owner: austriamicrosystems
// HIT-Kit: Digital
// ************************ SIMULATION PARAMETERS ************************
//  ----------------------------------------------------------------------
//  format    : Spectre (Spectre Direct)
//  model     : MOS BSIM3v3
//  process   : C35
//  revision  : 5.0;
//  extracted : B27167L1W5C45; 15-04-2007; bse (5866)
//  doc#      : Eng-182 REV_6
//  ----------------------------------------------------------------------
//                        MONTE-CARLO SIMULATION
//
//  ----------------------------------------------------------------------
//
inline subckt modpml ( d g s b )
parameters w=1.0e-6 l=1.0e-6 nrd=0.0 nrs=0.0 ad=0.0 as=0.0 pd=0.0 ps=0.0 ng=1
+ ws= w
+ ls= l
+ shk=1
+ dvthmat=(mv_modpml)*(1.8e-08/sqrt(ls*ws*ng)) dumat=(mu_modpml)*(6.3e-9/sqrt(ls*ws*ng))
+ dnoia=noia6*((1.173e+00)*exp((-8.200e-02)*ls*ws*1e12)+(1.618e+00))
//
if (modpml==1)
modpml ( d g s b ) mosinsub w=ws l=ls nrd=6.0000e-07/ws nrs=6.0000e-07/ws ad=ad as=as pd=pd ps=ps m=ng
else
modpml ( d s ) resistor r=1e30
notvalid paramtest errorif=(modpml==0) \
message="
***************************************************
*
* pmosml is not valid in selected process option.
*
***************************************************"
model mosinsub bsim3v3 version=3.2400e+00  type=p  capmod=2.0000e+00 \
 mobmod=1.0000e+00  nqsmod=0.0000e+00  noimod=3.0000e+00 \
   vbox=1.000e+03      k1=6.7600e-01 \
     k2=-4.000e-03      k3=1.7420e+01     k3b=-1.738e+00 \
    nch=npeak6 vth0=-6.880e-01+delvtopmlv+dvthmat \
   voff=-1.960e-01    dvt0=1.0000e+00    dvt1=4.2050e-01 \
   dvt2=-4.410e-02    keta=6.0000e-03 \
 pscbe1=1.0000e+30  pscbe2=1.0000e-06 \
 alpha0=1.3000e-07  alpha1=3.3320e-02   beta0=2.4820e+01 \
  dvt0w=5.7320e-01   dvt1w=2.8750e+05   dvt2w=1.6680e-01 \
     ua=3.3110e-09      ub=1.0000e-19      uc=-8.710e-11 \
u0=2.3600e+02+deluopmlv+(2.3600e+02+deluopmlv)*dumat \
   dsub=5.0000e-01    eta0=1.2500e-01    etab=-3.726e-04 \
nfactor=1.0210e+00 \
     em=4.1000e+07    pclm=2.5000e+00 \
  drout=5.0000e-01 \
     a0=1.1720e+00      a1=-1.581e-01      a2=1.0000e+00 \
   pvag=0.0000e+00    vsat=1.5690e+05     ags=1.4450e-01      b0=6.1800e-08      b1=0.0000e+00 \
  delta=2.9180e-02 pdiblcb=8.4520e-01 \
pdiblc1=1.1270e-02 pdiblc2=1.2500e-03 \
     w0=1.3800e-06 \
    dlc=4.5000e-08 \
    dwc=1.2300e-07     dwb=5.5110e-09     dwg=-5.171e-09 \
     ll=0.0000e+00      lw=0.0000e+00     lwl=0.0000e+00 \
    lln=1.0000e+00     lwn=1.0000e+00      wl=0.0000e+00 \
     ww=-4.460e-14     wwl=0.0000e+00     wln=1.0000e+00 \
     wr=1.0000e+00     wwn=1.0000e+00 \
     at=3.0000e+03     ute=-1.628e+00 \
    kt1=-6.603e-01     kt2=-8.840e-02    kt1l=0.0000e+00 \
    ua1=-2.399e-09     ub1=0.0000e+00     uc1=0.0000e+00 \
    prt=0.0000e+00 \
   cgso=cgsdopmlv        cgdo=cgsdopmlv        cgbo=cgbopmlv      \
   cgdl=1.6000e-10    cgsl=1.6000e-10  ckappa=1.4370e+00 \
     cf=0.0000e+00     elm=5.0000e+00 \
  xpart=1.0000e+00     clc=1.0000e-15     cle=6.0000e-01 \
\
   rdsw=6.3530e+02 \
   cdsc=1.4540e-04   cdscb=-2.792e-05   cdscd=0.0000e+00 \
   prwb=-3.097e-01    prwg=0.0000e+00     cit=0.0000e+00 \
tox=1.5700e-08+deltgoxmlv \
  ngate=1.0000e+00 \
    nlx=2.9510e-07 \
     xl=0.0000e+00+dellmlv      xw=0.0000e+00+delwmlv \
     af=1.5420e+00      kf=8.4060e-27      ef=1.0000e+00 \
 noia=min(exp(ln(3.138e+18)+dnoia),1.197e+19) noib=min(exp(noib6),2.661e+04)   noic=5.0080e-13 \
     rd=0.0000e+00      rs=0.0000e+00     rsh=1.3000e+02+drdiffp \
   minr=1.000e-03 \
    rdc=0.0000e+00     rsc=0.0000e+00 lint=-7.553e-08 \
wint=1.2300e-07   ldif=0.000e+00    hdif=6.0000e-07 \
     xj=3.0000e-07      js=2.8000e-07 \
      n=1.0000e+00 \
  dskip=no          tlev=0           tlevc=0         \
    jsw=3.7000e-13 \
     cj=cj6    cjsw=cjsw6 \
     fc=0.0000e+00    fcsw=0.000e+00 \
     mj=5.4000e-01    mjsw=4.6000e-01 \
     pb=1.0200e+00    pbsw=1.0200e+00     xti=1.9700e+00
ends modpml

// ----------------------------------------------------------------------

//----------------------------------------------------------------------
//************************* SIMULATION PARAMETERS ************************
// ----------------------------------------------------------------------
// format    : Spectre ( Spectre Direct )
// model     : DIODE
// process   : C35
// revision  : 4.0;
// extracted : B10866 ; 2002-12; ese(5487)
// doc#      : ENG-182 REV_6
// ----------------------------------------------------------------------
//                       MONTE-CARLO SIMULATION
// ----------------------------------------------------------------------
// TERMINALS: A=anode=P-region C=cathode=N-region
// VARIABLES: M (mulitiplier), AREA [m^2], PERI [m].
// NOTE: The role of a protection DIODE is to conduct ESD current to VDD
// (or from VSS). This forward bias is NOT modelled, only leakage current
// and capacitance during normal operation. Any inductive load etc that
// will give forward bias, must be limited by other components to within
// Operating Conditions, otherwise parasitic bipolar action can occur.
//
// Parameters: area perim
//
inline subckt nd ( a c )
parameters area=1.0e-12 perimeter=1.0e-6
//
if (subdiode==1)
nd ( a c ) diodeinsub area=area perim=perimeter region=off
else
nd ( a c ) resistor r=1e30
notvalid paramtest errorif=(subdiode==0) \
message="
***************************************************
*
* subdiode is not valid in selected process option.
*
***************************************************"
model diodeinsub diode level=1 dskip=no \
     is=5.1000e-07     isw=6.0000e-13       n=1.0000e+00      ns=1.0000e+00 \
   minr=0.100e+00    imax=(1.000e+00/area) \
    cjo=cj7       m=3.4000e-01      vj=6.9000e-01      tt=0.000e+00 \
    xti=2.0260e+00 \
   cjsw=cjsw7    mjsw=2.3000e-01    vjsw=6.9000e-01      fc=0.000e+00 \
     af=1.000e+00      kf=0.000e+00
ends nd
// ----------------------------------------------------------------------
// Owner: austriamicrosystems
// HIT-Kit: Digital
// ************************ SIMULATION PARAMETERS ************************
//  ----------------------------------------------------------------------
//  format    : Spectre (Spectre Direct)
//  model     : MOS BSIM3v3
//  process   : C35
//  revision  : 4.1;
//  extracted : C64685 ; 2002-12; ese(5487)
//  doc#      : ENG-182 REV_6
//  ----------------------------------------------------------------------
//                        MONTE-CARLO SIMULATION
//
//  ----------------------------------------------------------------------
//
inline subckt modp ( d g s b )
parameters w=1.0e-6 l=1.0e-6 nrd=0.0 nrs=0.0 ad=0.0 as=0.0 pd=0.0 ps=0.0 ng=1
+ ws= w
+ ls= l
+ shk=1
+ dvthmat=(mv_modp)*(1.03e-08/sqrt(ls*ws*ng)) dumat=(mu_modp)*(7.1e-9/sqrt(ls*ws*ng))
+ dkf=1.1910e-26*((-2.038e+00)*exp((-0.112e+00)*ls*ws*1e12)+(-0.402e+00))
+ dnoia=noia8*((1.446e+00)*exp((-1.500e-02)*ls*ws*1e12)+(1.430e+00))
//
if (modp==1)
modp ( d g s b ) mosinsub w=ws l=ls nrd=nrd nrs=nrs ad=ad as=as pd=pd ps=ps m=ng
else
modp ( d s ) resistor r=1e30
notvalid paramtest errorif=(modp==0) \
message="
***************************************************
*
* pmos is not valid in selected process option.
*
***************************************************"
model mosinsub bsim3v3 version=3.2400e+00  type=p  capmod=2.0000e+00 \
 mobmod=1.0000e+00  nqsmod=0.0000e+00  noimod=3 \
   vbox=1.000e+03      k1=5.5450e-01 \
     k2=-4.721e-02      k3=1.1030e+01     k3b=-7.580e-01 \
    nch=npeak8 vth0=-6.915e-01+delvtop+dvthmat \
   voff=-1.170e-01    dvt0=1.6500e+00    dvt1=3.8680e-01 \
   dvt2=1.6590e-02    keta=-1.440e-02 \
 pscbe1=1.0000e+30  pscbe2=1.0000e-06 \
 alpha0=1.0000e-09  alpha1=1.5000e+00   beta0=3.2500e+01 \
  dvt0w=1.8790e-01   dvt1w=7.3350e+04   dvt2w=-6.312e-03 \
     ua=5.3940e-10      ub=1.0530e-18      uc=1.0000e-20 \
u0=1.4820e+02+deluop+(1.4820e+02+deluop)*dumat \
   dsub=5.0000e-01    eta0=2.4800e-01    etab=-3.917e-03 \
nfactor=1.2140e+00 \
     em=4.1000e+07    pclm=3.1840e+00 \
  drout=5.0000e-01 \
     a0=5.8500e-01      a1=0.0000e+00      a2=1.0000e+00 \
   pvag=0.0000e+00    vsat=1.1580e+05     ags=2.4680e-01      b0=8.8320e-08      b1=0.0000e+00 \
  delta=1.0000e-02 pdiblcb=1.0000e+00 \
pdiblc1=1.0000e-04 pdiblc2=1.0000e-20 \
     w0=1.0000e-10 \
    dlc=2.4500e-08 \
    dwc=3.4490e-08     dwb=0.0000e+00     dwg=0.0000e+00 \
     ll=0.000e+00      lw=0.000e+00     lwl=0.000e+00 \
    lln=1.000e+00     lwn=1.000e+00      wl=0.0000e+00 \
     ww=1.8940e-16     wwl=-1.981e-21     wln=1.0000e+00 \
     wr=1.0000e+00     wwn=1.0400e+00 \
     at=3.3000e+04     ute=-1.300e+00 \
    kt1=-5.403e-01     kt2=2.2000e-02    kt1l=0.0000e+00 \
    ua1=0.0000e+00     ub1=0.0000e+00     uc1=0.0000e+00 \
    prt=0.0000e+00 \
   cgso=cgsdop        cgdo=cgsdop        cgbo=cgbop      \
   cgdl=1.0800e-10    cgsl=1.0800e-10  ckappa=6.0000e-01 \
     cf=0.0000e+00     elm=5.0000e+00 \
  xpart=1.0000e+00     clc=1.0000e-15     cle=6.0000e-01 \
   noff=1.0000e+00  voffcv=0.0000e+00 \
   rdsw=1.0330e+03 \
   cdsc=2.5890e-03   cdscb=2.9430e-04   cdscd=4.3700e-04 \
   prwb=-9.731e-02    prwg=1.4770e-01     cit=0.0000e+00 \
tox=7.7540e-09+deltgox \
  ngate=0.0000e+00 \
    nlx=1.7700e-07 \
     xl=0.0000e+00+dell      xw=0.0000e+00+delw \
     af=1.4610e+00  kf=min(exp(ln(1.191e-26)+dkf),1.827e-26)     ef=1.0000e+00 \
 noia=min(exp(ln(5.245e+17)+dnoia),7.091e+18) noib=min(exp(noib8),6.074e+04)   noic=8.0360e-13 \
     rd=0.0000e+00      rs=0.0000e+00     rsh=1.2900e+02+drdiffp \
   minr=1.000e-03 \
    rdc=0.0000e+00     rsc=0.0000e+00 lint=-7.130e-08 \
wint=3.4490e-08   ldif=0.000e+00    hdif=8.0000e-07 \
     xj=3.0000e-07      js=2.8000e-07 \
      n=1.0000e+00 \
  dskip=no          tlev=0           tlevc=0         \
    jsw=3.7000e-13 \
     cj=cj8    cjsw=cjsw8 \
     fc=0.0000e+00    fcsw=0.000e+00 \
     mj=5.4000e-01    mjsw=4.6000e-01 \
     pb=1.0200e+00    pbsw=1.0200e+00     xti=1.9730e+00
ends modp

// ----------------------------------------------------------------------

// ----------------------------------------------------------------------
// Owner: austriamicrosystems
// HIT-Kit: Digital
// ************************ SIMULATION PARAMETERS ************************
//  ----------------------------------------------------------------------
//  format    : Spectre (Spectre Direct)
//  model     : MOS BSIM3v3
//  process   : C35
//  revision  : 5.0;
//  extracted : B27167L1W5C45; 15-04-2007; bse (5866)
//  doc#      : Eng-182 REV_6
//  ----------------------------------------------------------------------
//                        MONTE-CARLO SIMULATION
//
//  ----------------------------------------------------------------------
//
inline subckt modpl ( d g s b )
parameters w=1.0e-6 l=1.0e-6 nrd=0.0 nrs=0.0 ad=0.0 as=0.0 pd=0.0 ps=0.0 ng=1
+ ws= w
+ ls= l
+ shk=1
+ dvthmat=(mv_modpl)*(1.24e-08/sqrt(ls*ws*ng)) dumat=(mu_modpl)*(5.7e-9/sqrt(ls*ws*ng))
+ dnoia=noia9*((1.987e+00)*exp((-1.250e-01)*ls*ws*1e12)+(1.652e+00))
//
if (modpl==1)
modpl ( d g s b ) mosinsub w=ws l=ls nrd=8.0000e-07/ws nrs=8.0000e-07/ws ad=ad as=as pd=pd ps=ps m=ng
else
modpl ( d s ) resistor r=1e30
notvalid paramtest errorif=(modpl==0) \
message="
***************************************************
*
* pmosl is not valid in selected process option.
*
***************************************************"
model mosinsub bsim3v3 version=3.2400e+00  type=p  capmod=2.0000e+00 \
 mobmod=1.0000e+00  nqsmod=0.0000e+00  noimod=3.0000e+00 \
   vbox=1.000e+03      k1=6.8800e-01 \
     k2=-7.790e-02      k3=5.2610e+01     k3b=7.2440e+00 \
    nch=npeak9 vth0=-5.240e-01+delvtoptlv+dvthmat \
   voff=-2.280e-01    dvt0=1.0460e+00    dvt1=3.9190e-01 \
   dvt2=1.9100e-03    keta=-2.400e-03 \
 pscbe1=1.0000e+30  pscbe2=1.0000e-06 \
 alpha0=1.1750e-08  alpha1=1.0000e-03   beta0=1.9580e+01 \
  dvt0w=1.0000e+00   dvt1w=5.3000e+06   dvt2w=9.5620e-02 \
     ua=1.0000e-12      ub=1.9050e-18      uc=6.3100e-11 \
u0=1.4500e+02+deluoptlv+(1.4500e+02+deluoptlv)*dumat \
   dsub=5.0000e-01    eta0=1.9590e-01    etab=0.0000e+00 \
nfactor=1.5790e+00 \
     em=4.1000e+07    pclm=8.2410e-01 \
  drout=5.0000e-01 \
     a0=5.0000e-01      a1=0.0000e+00      a2=1.0000e+00 \
   pvag=0.0000e+00    vsat=9.8190e+04     ags=2.6300e-01      b0=6.0600e-08      b1=0.0000e+00 \
  delta=4.3330e-03 pdiblcb=9.6330e-01 \
pdiblc1=1.0000e-03 pdiblc2=1.3800e-03 \
     w0=1.9050e-06 \
    dlc=2.0000e-08 \
    dwc=7.2920e-08     dwb=1.6220e-08     dwg=0.0000e+00 \
     ll=0.0000e+00      lw=0.0000e+00     lwl=0.0000e+00 \
    lln=1.0000e+00     lwn=1.0000e+00      wl=0.0000e+00 \
     ww=-2.000e-14     wwl=0.0000e+00     wln=1.0000e+00 \
     wr=1.0000e+00     wwn=1.0400e+00 \
     at=3.3000e+04     ute=-1.280e+00 \
    kt1=-5.577e-01     kt2=-6.560e-02    kt1l=0.0000e+00 \
    ua1=0.0000e+00     ub1=0.0000e+00     uc1=0.0000e+00 \
    prt=0.0000e+00 \
   cgso=cgsdoplv        cgdo=cgsdoplv        cgbo=cgboplv      \
   cgdl=2.4000e-10    cgsl=2.4000e-10  ckappa=5.6400e-01 \
     cf=0.0000e+00     elm=5.0000e+00 \
  xpart=1.0000e+00     clc=1.0000e-15     cle=6.0000e-01 \
\
   rdsw=2.0890e+03 \
   cdsc=1.3750e-03   cdscb=4.4880e-04   cdscd=1.9130e-04 \
   prwb=3.8020e-02    prwg=-1.047e-01     cit=0.0000e+00 \
tox=7.6600e-09+deltgoxtlv \
  ngate=1.0000e+00 \
    nlx=1.6220e-07 \
     xl=0.0000e+00+delltlv      xw=0.0000e+00+delwtlv \
     af=1.4350e+00      kf=4.0400e-27      ef=1.0000e+00 \
 noia=min(exp(ln(8.089e+18)+dnoia),2.922e+19) noib=min(exp(noib9),1.773e+04)   noic=4.6050e-13 \
     rd=0.0000e+00      rs=0.0000e+00     rsh=1.2900e+02+drdiffp \
   minr=1.000e-03 \
    rdc=0.0000e+00     rsc=0.0000e+00 lint=-1.285e-08 \
wint=7.2920e-08   ldif=0.000e+00    hdif=8.0000e-07 \
     xj=3.0000e-07      js=2.8000e-07 \
      n=1.0000e+00 \
  dskip=no          tlev=0           tlevc=0         \
    jsw=3.7000e-13 \
     cj=cj9    cjsw=cjsw9 \
     fc=0.0000e+00    fcsw=0.000e+00 \
     mj=5.4000e-01    mjsw=4.6000e-01 \
     pb=1.0200e+00    pbsw=1.0200e+00     xti=1.9700e+00
ends modpl

// ----------------------------------------------------------------------

//----------------------------------------------------------------------
//************************* SIMULATION PARAMETERS ************************
// ----------------------------------------------------------------------
// format    : Spectre ( Spectre Direct )
// model     : DIODE
// process   : C35
// revision  : 4.1;
// extracted : C64685 ; 2002-12; ese(5487)
// doc#      : ENG-182 REV_6
// ----------------------------------------------------------------------
//                       MONTE-CARLO SIMULATION
// ----------------------------------------------------------------------
// TERMINALS: A=anode=P-region C=cathode=N-region
// VARIABLES: M (mulitiplier), AREA [m^2], PERI [m].
// NOTE: The role of a protection DIODE is to conduct ESD current to VDD
// (or from VSS). This forward bias is NOT modelled, only leakage current
// and capacitance during normal operation. Any inductive load etc that
// will give forward bias, must be limited by other components to within
// Operating Conditions, otherwise parasitic bipolar action can occur.
//
// Parameters: area perim
//
inline subckt pd ( a c )
parameters area=1.0e-12 perimeter=1.0e-6
//
if (welldiode==1)
pd ( a c ) diodeinsub area=area perim=perimeter region=off
else
pd ( a c ) resistor r=1e30
notvalid paramtest errorif=(welldiode==0) \
message="
***************************************************
*
* welldiode is not valid in selected process option.
*
***************************************************"
model diodeinsub diode level=1 dskip=no \
     is=2.8000e-07     isw=3.7000e-13       n=1.0000e+00      ns=1.0000e+00 \
   minr=0.100e+00    imax=(1.000e+00/area) \
    cjo=cj10       m=5.4000e-01      vj=1.0200e+00      tt=0.000e+00 \
    xti=1.9730e+00 \
   cjsw=cjsw10    mjsw=4.6000e-01    vjsw=1.0200e+00      fc=0.000e+00 \
     af=1.000e+00      kf=0.000e+00
ends pd
// ----------------------------------------------------------------------
// Owner: austriamicrosystems
// HIT-Kit: Digital
// ************************ SIMULATION PARAMETERS ************************
//  ----------------------------------------------------------------------
//  format    : Spectre (Spectre Direct)
//  model     : MOS BSIM3v3
//  process   : C35
//  revision  : 4.1;
//  extracted : C35 B11004.L2; 2002-11; hhl(5481)
//  doc#      : Eng-182  REV_6.0
//  ----------------------------------------------------------------------
//                       MONTE-CARLO SIMULATION
//  ----------------------------------------------------------------------
//  HV-TRANSISTOR
//  ----------------------------------------------------------------------
inline subckt modnmh ( d g s b )
// Parameters: w l nrd nrs ad as pd ps
parameters w=1.0e-6 l=1.0e-6 nrd=0.0 nrs=0.0 ad=0.0 as=0.0 pd=0.0 ps=0.0 mult=1
+ ws=w
+ ls=l
+ dvthmat=mv_modnmh*(1.03e-08/sqrt(ls*ws*mult)) dumat=mu_modnmh*(3.5e-9/sqrt(ls*ws*mult))
//
if (modnmh==1){
modnmh ( d1 g s b ) mosinsub w=ws l=ls nrd=0 nrs=6.0000e-07/ws ad=ad as=as pd=pd ps=ps
rd ( d1 d ) resistor r=(rhv11*4.0000e-06/(ws)) tc1=6.2000e-03
}else
modnmh ( d s ) resistor r=1e30
notvalid paramtest errorif=(modnmh==0) \
message="
***************************************************
*
* nmosmh is not valid in selected process option.
*
***************************************************"
//
model mosinsub bsim3v3 version=3.1 type=n  capmod=2.0000e+00 \
 mobmod=1.0000e+00  nqsmod=0.0000e+00  noimod=3 \
   vbox=1.000e+03      k1=9.2609e-01 \
     k2=5.5988e-02      k3=-2.439e+00     k3b=4.0770e-01 \
    nch=npeak11 vth0=6.4490e-01+delvtonmh+dvthmat \
   voff=-4.948e-02    dvt0=4.9850e+01    dvt1=1.6830e+00 \
   dvt2=4.1260e-02    keta=-7.397e-02 \
 pscbe1=4.0000e+10  pscbe2=1.0000e-10 \
 alpha0=0.0000e+00   beta0=3.0000e+01 \
  dvt0w=0.0000e+00   dvt1w=0.0000e+00   dvt2w=0.0000e+00 \
     ua=1.0000e-12      ub=3.7680e-19      uc=6.3910e-12 \
u0=4.3940e+02+deluonmh+(4.3940e+02+deluonmh)*dumat \
   dsub=5.0000e-01    eta0=1.6160e-03    etab=-1.373e-02 \
nfactor=3.4550e-01 \
     em=4.1000e+07    pclm=1.0550e-01 \
  drout=5.0000e-01 \
     a0=2.1900e-01      a1=0.0000e+00      a2=1.0000e+00 \
   pvag=0.0000e+00    vsat=5.1290e+04     ags=9.4480e-02      b0=-3.629e-08      b1=0.0000e+00 \
  delta=3.3700e-03 pdiblcb=3.8720e-01 \
pdiblc1=1.0000e-10 pdiblc2=1.0000e-10 \
     w0=6.2890e-08 \
    dlc=8.9170e-08 \
    dwc=4.9380e-08     dwb=0.0000e+00     dwg=0.0000e+00 \
     ll=0.0000e+00      lw=0.0000e+00     lwl=0.0000e+00 \
    lln=1.0000e+00     lwn=1.0000e+00      wl=0.0000e+00 \
     ww=0.0000e+00     wwl=0.0000e+00     wln=1.0000e+00 \
     wr=1.0000e+00     wwn=1.0000e+00 \
   tnom=2.7000e+01      at=3.3000e+04     ute=-1.760e+00 \
    kt1=-4.502e-01     kt2=2.2000e-02    kt1l=0.0000e+00 \
    ua1=0.0000e+00     ub1=0.0000e+00     uc1=0.0000e+00 \
    prt=0.0000e+00 \
   cgso=cgsdonm        cgdo=cgsdonm        cgbo=cgbonm      \
   cgdl=0.0000e+00    cgsl=0.0000e+00  ckappa=6.0000e-01 \
     cf=0.0000e+00     elm=5.0000e+00 \
  xpart=1.0000e+00     clc=1.0000e-15     cle=6.0000e-01 \
\
   rdsw=5.3040e+02 \
   cdsc=1.0000e-02   cdscb=0.0000e+00   cdscd=8.4480e-05 \
   prwb=0.0000e+00    prwg=0.0000e+00     cit=8.1220e-04 \
tox=1.5140e-08+deltgoxm \
  ngate=0.0000e+00 \
    nlx=1.5930e-07 \
     xl=-1.050e-06+dellm      xw=0.0000e+00+delwm \
     af=1.3580e+00      kf=3.4460e-26      ef=1.0000e+00 \
   noia=1.7020e+20  noib=min(5.4630e+05,5.463e+05)   noic=-1.400e-11 \
     rd=0.0000e+00      rs=0.0000e+00     rsh=7.9460e+01+drdiffn \
   minr=1.000e-03 \
    rdc=0.0000e+00     rsc=0.0000e+00 lint=8.9170e-08 \
wint=4.9380e-08   ldif=0.000e+00    hdif=6.0000e-07 \
     xj=3.0000e-07      js=5.1000e-07 \
      n=1.0000e+00 \
  dskip=no          tlev=0           tlevc=0         \
    jsw=6.0000e-13 \
     cj=cj11    cjsw=cjsw11 \
     fc=0.0000e+00    fcsw=0.000e+00 \
     mj=3.9000e-01    mjsw=2.7000e-01 \
     pb=5.3000e-01    pbsw=6.9000e-01     xti=2.0260e+00
ends modnmh
// ----------------------------------------------------------------------
// Owner: austriamicrosystems
// HIT-Kit: Digital
// ************************ SIMULATION PARAMETERS ************************
//  ----------------------------------------------------------------------
//  format    : Spectre (Spectre Direct)
//  model     : MOS BSIM3v3
//  process   : c35
//  revision  : 4.1;
//  extracted : Wafer B26654W01 2005/10/10 REVISION 4.0; wpc(5481)
//  doc#      : Eng-182  REV 6.0
//  ----------------------------------------------------------------------
//                       MONTE-CARLO SIMULATION
//  ----------------------------------------------------------------------
//  HV-TRANSISTOR
//  ----------------------------------------------------------------------
inline subckt modnmhl ( d g s b )
// Parameters: w l nrd nrs ad as pd ps
parameters w=1.0e-6 l=1.0e-6 nrd=0.0 nrs=0.0 ad=0.0 as=0.0 pd=0.0 ps=0.0 mult=1
+ ws=w
+ ls=l
+ dvthmat=mv_modnmhl*(0.95e-08/sqrt(ls*ws*mult)) dumat=mu_modnmhl*(3.5e-9/sqrt(ls*ws*mult))
//
if (modnmhl==1){
modnmhl ( d1 g s b ) mosinsub w=ws l=ls nrd=0 nrs=8.0000e-07/ws ad=ad as=as pd=pd ps=ps
rd ( d1 d ) resistor r=(rhv12*4.0000e-06/(ws+(0.0000e+00))) tc1=6.2000e-03
}else
modnmhl ( d s ) resistor r=1e30
notvalid paramtest errorif=(modnmhl==0) \
message="
***************************************************
*
* nmosmhl is not valid in selected process option.
*
***************************************************"
//
model mosinsub bsim3v3 version=3.1 type=n  capmod=2.0000e+00 \
 mobmod=1.0000e+00  nqsmod=0.0000e+00  noimod=3 \
   vbox=1.000e+03      k1=7.4931e-01 \
     k2=5.8872e-02      k3=0.0000e+00     k3b=0.0000e+00 \
    nch=npeak12 vth0=4.9500e-01+delvtonmh+dvthmat \
   voff=-5.565e-02    dvt0=0.0000e+00    dvt1=1.6830e+00 \
   dvt2=4.1260e-02    keta=-8.210e-02 \
 pscbe1=4.0000e+10  pscbe2=1.0000e-10 \
 alpha0=0.0000e+00   beta0=3.0000e+01 \
  dvt0w=0.0000e+00   dvt1w=0.0000e+00   dvt2w=0.0000e+00 \
     ua=2.2380e-10      ub=0.0000e+00      uc=-1.429e-11 \
u0=5.1100e+02+deluonmh+(5.1100e+02+deluonmh)*dumat \
   dsub=5.0000e-01    eta0=1.6160e-03    etab=-1.373e-02 \
nfactor=8.5500e-01 \
     em=4.1000e+07    pclm=1.0550e-01 \
  drout=5.0000e-01 \
     a0=4.7540e-02      a1=0.0000e+00      a2=1.0000e+00 \
   pvag=0.0000e+00    vsat=5.2060e+04     ags=-3.227e-01      b0=0.0000e+00      b1=0.0000e+00 \
  delta=1.5850e-02 pdiblcb=3.8720e-01 \
pdiblc1=1.0000e-10 pdiblc2=1.0000e-10 \
     w0=0.0000e+00 \
    dlc=0.0000e+00 \
    dwc=0.0000e+00     dwb=0.0000e+00     dwg=0.0000e+00 \
     ll=0.0000e+00      lw=0.0000e+00     lwl=0.0000e+00 \
    lln=1.0000e+00     lwn=1.0000e+00      wl=0.0000e+00 \
     ww=0.0000e+00     wwl=0.0000e+00     wln=1.0000e+00 \
     wr=1.0000e+00     wwn=1.0000e+00 \
     at=3.3000e+04     ute=-1.720e+00 \
    kt1=-4.202e-01     kt2=2.2000e-02    kt1l=0.0000e+00 \
    ua1=0.0000e+00     ub1=0.0000e+00     uc1=0.0000e+00 \
    prt=0.0000e+00 \
   cgso=cgsdonm        cgdo=cgsdonm        cgbo=cgbonm      \
   cgdl=0.0000e+00    cgsl=0.0000e+00  ckappa=6.0000e-01 \
     cf=0.0000e+00     elm=5.0000e+00 \
  xpart=1.0000e+00     clc=1.0000e-15     cle=6.0000e-01 \
\
   rdsw=5.3040e+02 \
   cdsc=0.0000e+00   cdscb=0.0000e+00   cdscd=0.0000e+00 \
   prwb=0.0000e+00    prwg=0.0000e+00     cit=2.9310e-05 \
tox=1.5420e-08+deltgoxm \
  ngate=0.0000e+00 \
    nlx=1.5930e-07 \
     xl=0.0000e+00+dellm      xw=0.0000e+00+delwm \
     af=1.4000e+00      kf=3.7700e-26      ef=1.0000e+00 \
   noia=1.5360e+20  noib=min(3.5840e+05,3.584e+05)   noic=-1.304e-11 \
     rd=0.0000e+00      rs=0.0000e+00     rsh=7.5000e+01+drdiffn \
   minr=1.000e-03 \
    rdc=0.0000e+00     rsc=0.0000e+00 lint=6.0000e-07 \
wint=0.0000e+00   ldif=0.000e+00    hdif=8.0000e-07 \
     xj=3.0000e-07      js=5.1000e-07 \
      n=1.0000e+00 \
  dskip=no          tlev=0           tlevc=0         \
    jsw=6.0000e-13 \
     cj=cj12    cjsw=cjsw12 \
     fc=0.0000e+00    fcsw=0.000e+00 \
     mj=3.4000e-01    mjsw=2.3000e-01 \
     pb=6.9000e-01    pbsw=6.9000e-01     xti=2.0300e+00
ends modnmhl
// ----------------------------------------------------------------------
// Owner: austriamicrosystems
// HIT-Kit: Digital
// ************************ SIMULATION PARAMETERS ************************
//  ----------------------------------------------------------------------
//  format    : Spectre (Spectre Direct)
//  model     : MOS BSIM3v3
//  process   : C35
//  revision  : 4.1;
//  extracted : C35 B11004.L2; 2002-11; hhl(5481)
//  doc#      : Eng-182  REV_6.0
//  ----------------------------------------------------------------------
//                       MONTE-CARLO SIMULATION
//  ----------------------------------------------------------------------
//  HV-TRANSISTOR
//  ----------------------------------------------------------------------
inline subckt modnh ( d g s b )
// Parameters: w l nrd nrs ad as pd ps
parameters w=1.0e-6 l=1.0e-6 nrd=0.0 nrs=0.0 ad=0.0 as=0.0 pd=0.0 ps=0.0 mult=1
+ ws=w
+ ls=l
+ dvthmat=mv_modnh*(0.67e-08/sqrt(ls*ws*mult)) dumat=mu_modnh*(4.9e-9/sqrt(ls*ws*mult))
//
if (modnh==1){
modnh ( d1 g s b ) mosinsub w=ws l=ls nrd=0 nrs=6.0000e-07/ws ad=ad as=as pd=pd ps=ps
rd ( d1 d ) resistor r=(rhv13*4.0000e-06/(ws)) tc1=6.2000e-03
}else
modnh ( d s ) resistor r=1e30
notvalid paramtest errorif=(modnh==0) \
message="
***************************************************
*
* nmosh is not valid in selected process option.
*
***************************************************"
//
model mosinsub bsim3v3 version=3.1 type=n  capmod=2.0000e+00 \
 mobmod=1.0000e+00  nqsmod=0.0000e+00  noimod=3 \
   vbox=1.000e+03      k1=6.5736e-01 \
     k2=-1.238e-02      k3=-2.240e+00     k3b=6.9540e-01 \
    nch=npeak13 vth0=4.4600e-01+delvton+dvthmat \
   voff=-5.090e-02    dvt0=4.9850e+01    dvt1=1.2960e+00 \
   dvt2=1.3110e-02    keta=-4.553e-02 \
 pscbe1=1.0000e+10  pscbe2=1.0240e-05 \
 alpha0=0.0000e+00   beta0=3.0000e+01 \
  dvt0w=0.0000e+00   dvt1w=0.0000e+00   dvt2w=0.0000e+00 \
     ua=1.0000e-30      ub=1.9490e-18      uc=1.2170e-10 \
u0=3.4270e+02+deluonh+(3.4270e+02+deluonh)*dumat \
   dsub=5.0000e-01    eta0=3.0750e-02    etab=-5.261e-02 \
nfactor=2.0340e-01 \
     em=4.1000e+07    pclm=2.9400e-01 \
  drout=5.0000e-01 \
     a0=1.8930e-01      a1=0.0000e+00      a2=1.0000e+00 \
   pvag=0.0000e+00    vsat=2.4020e+05     ags=1.2450e-01      b0=6.7900e-08      b1=0.0000e+00 \
  delta=1.7290e-02 pdiblcb=2.0670e-01 \
pdiblc1=3.0900e-02 pdiblc2=6.3750e-04 \
     w0=1.1450e-07 \
    dlc=6.0000e-07 \
    dwc=2.6050e-08     dwb=0.0000e+00     dwg=0.0000e+00 \
     ll=0.0000e+00      lw=0.0000e+00     lwl=0.0000e+00 \
    lln=1.0000e+00     lwn=1.0000e+00      wl=0.0000e+00 \
     ww=0.0000e+00     wwl=0.0000e+00     wln=1.0000e+00 \
     wr=1.0000e+00     wwn=1.0000e+00 \
   tnom=2.7000e+01      at=3.3000e+04     ute=-1.800e+00 \
    kt1=-3.302e-01     kt2=2.2000e-02    kt1l=0.0000e+00 \
    ua1=0.0000e+00     ub1=0.0000e+00     uc1=0.0000e+00 \
    prt=0.0000e+00 \
   cgso=cgsdon        cgdo=cgsdon        cgbo=cgbon      \
   cgdl=0.0000e+00    cgsl=0.0000e+00  ckappa=6.0000e-01 \
     cf=0.0000e+00     elm=5.0000e+00 \
  xpart=1.0000e+00     clc=1.0000e-15     cle=6.0000e-01 \
\
   rdsw=1.0920e+03 \
   cdsc=7.9440e-03   cdscb=0.0000e+00   cdscd=8.4480e-05 \
   prwb=0.0000e+00    prwg=0.0000e+00     cit=1.0000e-03 \
tox=7.7000e-09+deltgox \
  ngate=0.0000e+00 \
    nlx=1.1320e-07 \
     xl=0.0000e+00+dell      xw=0.0000e+00+delw \
     af=1.3580e+00      kf=3.4460e-26      ef=1.0000e+00 \
   noia=1.7020e+20  noib=min(5.4630e+05,5.463e+05)   noic=-1.400e-11 \
     rd=0.0000e+00      rs=0.0000e+00     rsh=8.2000e+01+drdiffn \
   minr=1.000e-03 \
    rdc=0.0000e+00     rsc=0.0000e+00 lint=6.0000e-07 \
wint=2.6050e-08   ldif=0.000e+00    hdif=6.0000e-07 \
     xj=3.0000e-07      js=5.1000e-07 \
      n=1.0000e+00 \
  dskip=no          tlev=0           tlevc=0         \
    jsw=6.0000e-13 \
     cj=cj13    cjsw=cjsw13 \
     fc=0.0000e+00    fcsw=0.000e+00 \
     mj=3.9000e-01    mjsw=2.7000e-01 \
     pb=5.3000e-01    pbsw=6.9000e-01     xti=2.0260e+00
ends modnh
// ----------------------------------------------------------------------
// Owner: austriamicrosystems
// HIT-Kit: Digital
// ************************ SIMULATION PARAMETERS ************************
//  ----------------------------------------------------------------------
//  format    : Spectre (Spectre Direct)
//  model     : MOS BSIM3v3
//  process   : c35
//  revision  : 4.0;
//  extracted : Wafer B26654W01 2005/10/05 REVISION 4.0; wpc(5481)
//  doc#      : Eng-182  REV 6.0
//  ----------------------------------------------------------------------
//                       MONTE-CARLO SIMULATION
//  ----------------------------------------------------------------------
//  HV-TRANSISTOR
//  ----------------------------------------------------------------------
inline subckt modnhl ( d g s b )
// Parameters: w l nrd nrs ad as pd ps
parameters w=1.0e-6 l=1.0e-6 nrd=0.0 nrs=0.0 ad=0.0 as=0.0 pd=0.0 ps=0.0 mult=1
+ ws=w
+ ls=l
+ dvthmat=mv_modnhl*(0.67e-08/sqrt(ls*ws*mult)) dumat=mu_modnhl*(4.9e-9/sqrt(ls*ws*mult))
//
if (modnhl==1){
modnhl ( d1 g s b ) mosinsub w=ws l=ls nrd=0 nrs=8.0000e-07/ws ad=ad as=as pd=pd ps=ps
rd ( d1 d ) resistor r=(rhv14*4.0000e-06/(ws+(0.0000e+00))) tc1=6.2000e-03
}else
modnhl ( d s ) resistor r=1e30
notvalid paramtest errorif=(modnhl==0) \
message="
***************************************************
*
* nmoshl is not valid in selected process option.
*
***************************************************"
//
model mosinsub bsim3v3 version=3.1 type=n  capmod=2.0000e+00 \
 mobmod=1.0000e+00  nqsmod=0.0000e+00  noimod=3 \
   vbox=1.000e+03      k1=5.0855e-01 \
     k2=-0.0000e+00      k3=0.0000e+00     k3b=0.0000e+00 \
    nch=npeak14 vth0=3.6560e-01+delvton+dvthmat \
   voff=-5.119e-02    dvt0=0.0000e+00    dvt1=1.2960e+00 \
   dvt2=1.3110e-02    keta=-3.955e-02 \
 pscbe1=1.0000e+10  pscbe2=1.0240e-05 \
 alpha0=0.0000e+00   beta0=3.0000e+01 \
  dvt0w=0.0000e+00   dvt1w=0.0000e+00   dvt2w=0.0000e+00 \
     ua=1.0000e-30      ub=1.9490e-18      uc=1.2170e-10 \
u0=3.4270e+02+deluonh+(3.4270e+02+deluonh)*dumat \
   dsub=5.0000e-01    eta0=0.0000e+00    etab=0.0000e+00 \
nfactor=1.1530e+00 \
     em=4.1000e+07    pclm=2.9400e-01 \
  drout=5.0000e-01 \
     a0=3.3100e-01      a1=0.0000e+00      a2=1.0000e+00 \
   pvag=0.0000e+00    vsat=2.4020e+06     ags=3.2310e-01      b0=0.0000e+00      b1=0.0000e+00 \
  delta=3.1850e-02 pdiblcb=2.0670e-04 \
pdiblc1=3.0900e-02 pdiblc2=6.3750e-04 \
     w0=1.1450e-07 \
    dlc=0.0000e+00 \
    dwc=0.0000e+00     dwb=0.0000e+00     dwg=0.0000e+00 \
     ll=0.0000e+00      lw=0.0000e+00     lwl=0.0000e+00 \
    lln=1.0000e+00     lwn=1.0000e+00      wl=0.0000e+00 \
     ww=0.0000e+00     wwl=0.0000e+00     wln=1.0000e+00 \
     wr=1.0000e+00     wwn=1.0000e+00 \
     at=3.3000e+04     ute=-1.700e+00 \
    kt1=-3.001e-01     kt2=2.2000e-02    kt1l=0.0000e+00 \
    ua1=0.0000e+00     ub1=0.0000e+00     uc1=0.0000e+00 \
    prt=0.0000e+00 \
   cgso=cgsdon        cgdo=cgsdon        cgbo=cgbon      \
   cgdl=0.0000e+00    cgsl=0.0000e+00  ckappa=6.0000e-01 \
     cf=0.0000e+00     elm=5.0000e+00 \
  xpart=1.0000e+00     clc=1.0000e-15     cle=6.0000e-01 \
\
   rdsw=1.0920e+03 \
   cdsc=0.0000e+00   cdscb=0.0000e+00   cdscd=0.0000e+00 \
   prwb=0.0000e+00    prwg=0.0000e+00     cit=-2.050e-04 \
tox=7.6600e-09+deltgox \
  ngate=0.0000e+00 \
    nlx=1.1320e-07 \
     xl=0.0000e+00+dell      xw=0.0000e+00+delw \
     af=1.4000e+00      kf=3.7700e-26      ef=1.0000e+00 \
   noia=1.5360e+20  noib=min(3.5840e+05,3.584e+05)   noic=-1.304e-11 \
     rd=0.0000e+00      rs=0.0000e+00     rsh=7.5000e+01+drdiffn \
   minr=1.000e-03 \
    rdc=0.0000e+00     rsc=0.0000e+00 lint=6.0000e-07 \
wint=0.0000e+00   ldif=0.000e+00    hdif=8.0000e-07 \
     xj=3.0000e-07      js=5.1000e-07 \
      n=1.0000e+00 \
  dskip=no          tlev=0           tlevc=0         \
    jsw=6.0000e-13 \
     cj=cj14    cjsw=cjsw14 \
     fc=0.0000e+00    fcsw=0.000e+00 \
     mj=3.4000e-01    mjsw=2.3000e-01 \
     pb=6.9000e-01    pbsw=6.9000e-01     xti=2.0300e+00
ends modnhl
// ----------------------------------------------------------------------
// Owner: austriamicrosystems
// HIT-Kit: Digital
// ************************ SIMULATION PARAMETERS ************************
//  ----------------------------------------------------------------------
//  format    : Spectre (Spectre Direct)
//  model     : MOS BSIM3v3
//  process   : c35
//  revision  : ;
//  extracted : B58737.W09PE6; 2008-06; kmo(5966)
//  doc#      : ENG-327 Rev.2.0
//  ----------------------------------------------------------------------
//                       MONTE-CARLO SIMULATION
//  ----------------------------------------------------------------------
//  HV-TRANSISTOR
//  ----------------------------------------------------------------------
inline subckt modn30m ( d g s b )
// Parameters: w l nrd nrs ad as pd ps
parameters w=1.0e-6 l=1.0e-6 nrd=0.0 nrs=0.0 ad=0.0 as=0.0 pd=0.0 ps=0.0 mult=1 gv=(7.6860e-08/l + 9.1600e-01) dcdc=1
+ dvthmat=mv_modn30m*(0.56e-08/sqrt(l*w*mult)) dumat=mu_modn30m*(2.9e-9/sqrt(l*w*mult))
if (modn30m==1){
//
modn30m ( d1 g s1 b ) mosinsub w=w l=l nrd=0 nrs=8.0000e-07/w ad=0 as=as pd=0 ps=ps
rd ( d1 d ) resistor r=(rj15/(w+(1.6670e-06))) tc1=6.0000e-03
xj1 ( d gj d1 ) modn30mjfet1 w=w
xj2 ( d gj d1 ) modn30mjfet2 w=w
e1 ( d1 gj d1 s ) vcvs gain=gv min=-25 max=25
cgdx ( g d ) capacitor c=(cgdx115*w)
v1 ( s1 s ) vsource dc=0 type=dc
i1 ( d b ) bsource i=((6.1450e-10)/(l+(0.0000e+00))+(6.1590e-03))*i("v1:p")*(max((v(d,g)+(1.8290e-02)),1e-15))**(4.1480e+00)*exp((-1.4550e+01)/max((v(d,g)+(1.8290e-02)),1e-10))*(w+0.0000e+00)/w/(1+2.8000e+04*exp(7.7390e-03*i("v1:p")/(w+0.0000e+00)))
xdw ( b d1 ) modn30mnwd area=(1e-06*2.35*(w+1e-06*16)) perimeter=(4e-06*2.35+(w+1e-06*16))
}else
modn30m ( d s ) resistor r=1e30
notvalid paramtest errorif=(modn30m==0) \
message="
***************************************************
*
* nmos30m is not valid in selected process option.
*
***************************************************"
//
model mosinsub bsim3v3 version=3.1 type=n  capmod=2.0000e+00 \
 mobmod=1.0000e+00  nqsmod=0.0000e+00  noimod=3.0000e+00 \
   vbox=1.000e+03      k1=9.3509e-01 \
     k2=6.1371e-02      k3=2.3030e-01     k3b=-1.516e-02 \
    nch=npeak15 vth0=7.0770e-01+delvtonm+dvthmat \
   voff=-6.529e-02    dvt0=1.1390e-03    dvt1=1.0310e-01 \
   dvt2=-1.601e-01    keta=-1.236e-02 \
 pscbe1=3.5770e+12  pscbe2=5.7730e-12 \
 alpha0=0.0000e+00   beta0=3.0000e+01 \
  dvt0w=3.0490e-01   dvt1w=2.3530e+05   dvt2w=-2.685e+00 \
     ua=5.6220e-12      ub=9.5730e-19      uc=7.1200e-13 \
u0=4.4180e+02+deluonm+(4.4180e+02+deluonm)*dumat \
   dsub=5.2500e+00    eta0=1.0000e-07    etab=-3.000e-01 \
nfactor=9.0620e-01 \
     em=4.1000e+07    pclm=2.8550e+00 \
  drout=5.0000e-01 \
     a0=8.2080e-01      a1=0.0000e+00      a2=1.0000e+00 \
   pvag=0.0000e+00    vsat=8.9380e+04     ags=1.8620e-02      b0=3.0590e-09      b1=2.6720e-02 \
  delta=3.7770e-05 pdiblcb=1.0000e-12 \
pdiblc1=5.1750e-04 pdiblc2=3.7770e-07 \
     w0=-4.630e-06 \
    dlc=-5.451e-07 \
    dwc=2.7390e-07     dwb=0.0000e+00     dwg=0.0000e+00 \
     ll=0.0000e+00      lw=0.0000e+00     lwl=0.0000e+00 \
    lln=1.0000e+00     lwn=1.0000e+00      wl=0.0000e+00 \
     ww=0.0000e+00     wwl=0.0000e+00     wln=1.0000e+00 \
    wwn=1.0000e+00 \
     at=3.3000e+04     ute=-1.710e+00 \
    kt1=-4.600e-01     kt2=2.2000e-02    kt1l=0.0000e+00 \
    ua1=0.0000e+00     ub1=0.0000e+00     uc1=0.0000e+00 \
    prt=0.0000e+00 \
   cgso=cgsdonm        cgdo=1.0000e-15    cgbo=cgbonm      \
   cgdl=5.0000e-10    cgsl=4.8800e-10  ckappa=1.9890e+00 \
     cf=0.0000e+00     elm=5.0000e+00 \
  xpart=5.0000e-01     clc=1.0000e-15     cle=6.0000e-01 \
\
   rdsw=0.0000e+00 \
   cdsc=1.9360e-06   cdscb=1.0000e-12   cdscd=1.0740e-08 \
   prwb=0.0000e+00    prwg=0.0000e+00     cit=1.0740e-06 \
tox=1.5400e-08+deltgoxm \
  ngate=0.0000e+00 \
    nlx=2.6040e-07 \
     xl=0.0000e+00+dellm      xw=0.0000e+00+delwm \
     af=1.9886e+00      kf=1.6086e-24      ef=1.0000e+00 \
   noia=2.5794e+19  noib=min(1.0199e+05,1.0199164e+05)   noic=-2.372e-12 \
     rd=0.0000e+00      rs=0.0000e+00     rsh=7.5000e+01+drdiffn \
   minr=1.000e-03 \
    rdc=0.0000e+00     rsc=0.0000e+00 lint=-2.271e-07 \
wint=2.7390e-07   ldif=0.000e+00    hdif=8.0000e-07 \
     xj=9.0000e-07      js=3.5530e-07 \
      n=1.0000e+00 \
  dskip=no          tlev=0           tlevc=0         \
    jsw=1.7560e-12 \
     cj=cj15    cjsw=cjsw15 \
     fc=0.0000e+00    fcsw=0.000e+00 \
     mj=3.4000e-01    mjsw=2.3000e-01 \
     pb=6.9000e-01    pbsw=6.9000e-01     xti=2.0260e+00
ends modn30m
// HV-jfet 1
inline subckt modn30mjfet1 (d b s)
parameters w=1e-6
modn30mjfet1 (d b s) rnjfetinsub
model rnjfetinsub jfet type=n \
beta=beta115/(1+(2.8000e-03)*(temp-(2.7000e+01)))*(w+(1.6670e-06))/(1+(6.0000e-03)*(temp-27)) \
vto=-5.700e+00*(1+(2.8000e-03)*(temp-(2.7000e+01))) \
lambda=0.0000e+00 \
is=0.0000e+00  pb=5.0000e-01 \
cgs=0.0000e+00 rs=0.0000e+00 \
cgd=0.0000e+00 rd=0.0000e+00
ends modn30mjfet1
// HV-jfet 2
inline subckt  modn30mjfet2 (d b s)
parameters w=1e-6
modn30mjfet2 (d b s) rnjfetinsub
model rnjfetinsub jfet type=n \
beta=beta215/(1+(2.8000e-03)*(temp-(2.7000e+01)))*(w+(1.6670e-06))/(1+(6.0000e-03)*(temp-27)) \
vto=-7.957e+00*(1+(2.8000e-03)*(temp-(2.7000e+01))) \
lambda=0.0000e+00 \
is=0.0000e+00  pb=5.0000e-01 \
cgs=0.0000e+00 rs=0.0000e+00 \
cgd=0.0000e+00 rd=0.0000e+00
ends modn30mjfet2
//

inline subckt modn30mnwd ( a c )
parameters area=1.0e-12 perimeter=1.0e-6
modn30mnwd ( a c ) diodeinsub area=area perim=perimeter region=off
model diodeinsub diode level=1 dskip=no \
is=1.676e-06          isw=2.158e-11                n=1.000e+00 ns=1.000e+00 \
minr=0.100e+00   imax=(1.000e+00/area) \
cj0=8.798e-05        m=2.737e-01                  vj=5.300e-01 tt=0.000e+00 \
cjsw=6.611e-10       mjsw=2.122e-01             vjsw=5.300e-01 fc=0.000e+00\
af=1.000e+00     kf=0.000e+00            xti=1.366e+00
ends modn30mnwd
// ----------------------------------------------------------------------
// Owner: austriamicrosystems
// HIT-Kit: Digital
// ************************ SIMULATION PARAMETERS ************************
//  ----------------------------------------------------------------------
//  format    : Spectre (Spectre Direct)
//  model     : MOS BSIM3v3
//  process   : c35
//  revision  : ;
//  extracted : B58737.W09PE6; 2008-06; kmo(5966)
//  doc#      : ENG-327 Rev.2.0
//  ----------------------------------------------------------------------
//                       MONTE-CARLO SIMULATION
//  ----------------------------------------------------------------------
//  HV-TRANSISTOR
//  ----------------------------------------------------------------------
inline subckt modn18t ( d g s b )
// Parameters: w l nrd nrs ad as pd ps
parameters w=1.0e-6 l=1.0e-6 nrd=0.0 nrs=0.0 ad=0.0 as=0.0 pd=0.0 ps=0.0 mult=1 gv=(2.8290e-07/l + 8.9230e-01) dcdc=1
+ dvthmat=mv_modn18t*(0.78e-08/sqrt(l*w*mult)) dumat=mu_modn18t*(6.9e-09/sqrt(l*w*mult))
if (modn18t==1){
//
modn18t ( d1 g s1 b ) mosinsub w=w l=l nrd=0 nrs=8.0000e-07/w ad=0 as=as pd=0 ps=ps
rd ( d1 d ) resistor r=(rj16/(w+(2.4730e-06))) tc1=5.0000e-03
xj1 ( d gj d1 ) modn18tjfet1 w=w
xj2 ( d gj d1 ) modn18tjfet2 w=w
e1 ( d1 gj d1 s ) vcvs gain=gv min=-25 max=25
cgdx ( g d ) capacitor c=(cgdx116*w)
v1 ( s1 s ) vsource dc=0 type=dc
i1 ( d b ) bsource i=((5.3850e-10)/(l+(0.0000e+00))+(4.8260e-03))*i("v1:p")*(max((v(d,g)+(2.9600e-02)),1e-15))**(3.8580e+00)*exp((-4.2900e+00)/max((v(d,g)+(2.9600e-02)),1e-10))*(w+0.0000e+00)/w/(1+3.3810e+04*exp(5.3330e-03*i("v1:p")/(w+0.0000e+00)))
xdw ( b d1 ) modn18tnwd area=(1e-06*2.35*(w+1e-06*16)) perimeter=(4e-06*2.35+(w+1e-06*16))
}else
modn18t ( d s ) resistor r=1e30
notvalid paramtest errorif=(modn18t==0) \
message="
***************************************************
*
* nmos18t is not valid in selected process option.
*
***************************************************"
//
model mosinsub bsim3v3 version=3.1 type=n  capmod=2.0000e+00 \
 mobmod=1.0000e+00  nqsmod=0.0000e+00  noimod=3.0000e+00 \
   vbox=1.000e+03      k1=6.0871e-01 \
     k2=-3.258e-03      k3=-2.570e+00     k3b=1.9850e+00 \
    nch=npeak16 vth0=4.6760e-01+delvton+dvthmat \
   voff=-8.829e-02    dvt0=1.8190e-01    dvt1=1.0200e-01 \
   dvt2=-5.409e-02    keta=-3.582e-02 \
 pscbe1=3.5770e+12  pscbe2=5.7730e-12 \
 alpha0=0.0000e+00   beta0=3.0000e+01 \
  dvt0w=7.9230e-01   dvt1w=6.0330e+05   dvt2w=-2.792e+00 \
     ua=2.1750e-10      ub=4.8850e-19      uc=1.2070e-10 \
u0=3.8760e+02+deluon+(3.8760e+02+deluon)*dumat \
   dsub=5.2500e+00    eta0=1.0000e-07    etab=-3.000e-01 \
nfactor=8.6770e-01 \
     em=4.1000e+07    pclm=6.0510e+00 \
  drout=5.0000e-01 \
     a0=7.6440e-01      a1=0.0000e+00      a2=1.0000e+00 \
   pvag=0.0000e+00    vsat=5.5760e+04     ags=2.3440e-01      b0=4.4050e-09      b1=2.6720e-02 \
  delta=2.5490e-05 pdiblcb=1.0000e-12 \
pdiblc1=2.2650e+00 pdiblc2=1.0000e-09 \
     w0=-7.990e-01 \
    dlc=-7.640e-07 \
    dwc=1.6680e-07     dwb=0.0000e+00     dwg=0.0000e+00 \
     ll=0.0000e+00      lw=0.0000e+00     lwl=0.0000e+00 \
    lln=1.0000e+00     lwn=1.0000e+00      wl=0.0000e+00 \
     ww=0.0000e+00     wwl=0.0000e+00     wln=1.0000e+00 \
    wwn=1.0000e+00 \
     at=3.3000e+04     ute=-1.720e+00 \
    kt1=-3.210e-01     kt2=2.2000e-02    kt1l=0.0000e+00 \
    ua1=0.0000e+00     ub1=0.0000e+00     uc1=0.0000e+00 \
    prt=0.0000e+00 \
   cgso=cgsdon        cgdo=1.0000e-15    cgbo=cgbon      \
   cgdl=4.4020e-10    cgsl=5.0000e-10  ckappa=6.2280e-01 \
     cf=0.0000e+00     elm=5.0000e+00 \
  xpart=5.0000e-01     clc=1.0000e-15     cle=6.0000e-01 \
\
   rdsw=0.0000e+00 \
   cdsc=5.0330e-20   cdscb=2.9060e-04   cdscd=7.3780e-10 \
   prwb=0.0000e+00    prwg=0.0000e+00     cit=7.3780e-08 \
tox=7.6000e-09+deltgox \
  ngate=0.0000e+00 \
    nlx=1.4630e-07 \
     xl=0.0000e+00+dell      xw=0.0000e+00+delw \
     af=2.0045e+00      kf=8.5977e-25      ef=1.0000e+00 \
   noia=4.8618e+18  noib=min(2.9560e+04,2.9559852e+04)   noic=-2.148e-13 \
     rd=0.0000e+00      rs=0.0000e+00     rsh=7.5000e+01+drdiffn \
   minr=1.000e-03 \
    rdc=0.0000e+00     rsc=0.0000e+00 lint=-3.414e-07 \
wint=1.6680e-07   ldif=0.000e+00    hdif=8.0000e-07 \
     xj=9.0000e-07      js=3.5530e-07 \
      n=1.0000e+00 \
  dskip=no          tlev=0           tlevc=0         \
    jsw=1.7560e-12 \
     cj=cj16    cjsw=cjsw16 \
     fc=0.0000e+00    fcsw=0.000e+00 \
     mj=3.4000e-01    mjsw=2.3000e-01 \
     pb=6.9000e-01    pbsw=6.9000e-01     xti=2.0260e+00
ends modn18t
// HV-jfet 1
inline subckt modn18tjfet1 (d b s)
parameters w=1e-6
modn18tjfet1 (d b s) rnjfetinsub
model rnjfetinsub jfet type=n \
beta=beta116/(1+(1.6000e-03)*(temp-(2.7000e+01)))*(w+(2.4730e-06))/(1+(5.0000e-03)*(temp-27)) \
vto=-7.402e+00*(1+(1.6000e-03)*(temp-(2.7000e+01))) \
lambda=0.0000e+00 \
is=0.0000e+00  pb=5.0000e-01 \
cgs=0.0000e+00 rs=0.0000e+00 \
cgd=0.0000e+00 rd=0.0000e+00
ends modn18tjfet1
// HV-jfet 2
inline subckt  modn18tjfet2 (d b s)
parameters w=1e-6
modn18tjfet2 (d b s) rnjfetinsub
model rnjfetinsub jfet type=n \
beta=beta216/(1+(1.6000e-03)*(temp-(2.7000e+01)))*(w+(2.4730e-06))/(1+(5.0000e-03)*(temp-27)) \
vto=-7.947e+00*(1+(1.6000e-03)*(temp-(2.7000e+01))) \
lambda=0.0000e+00 \
is=0.0000e+00  pb=5.0000e-01 \
cgs=0.0000e+00 rs=0.0000e+00 \
cgd=0.0000e+00 rd=0.0000e+00
ends modn18tjfet2
//

inline subckt modn18tnwd ( a c )
parameters area=1.0e-12 perimeter=1.0e-6
modn18tnwd ( a c ) diodeinsub area=area perim=perimeter region=off
model diodeinsub diode level=1 dskip=no \
is=2.159e-06          isw=3.227e-11                n=1.000e+00 ns=1.000e+00 \
minr=0.100e+00   imax=(1.000e+00/area) \
cj0=8.992e-05        m=2.671e-01                  vj=5.300e-01 tt=0.000e+00 \
cjsw=6.406e-10       mjsw=2.161e-01             vjsw=5.300e-01 fc=0.000e+00\
af=1.000e+00     kf=0.000e+00            xti=4.786e-01
ends modn18tnwd

// ----------------------------------------------------------------------
// Owner: austriamicrosystems
// HIT-Kit: Digital
// ************************ SIMULATION PARAMETERS ************************
//  ----------------------------------------------------------------------
//  format    : Spectre (Spectre Direct)
//  model     : MOS HiSIM_HV
//  process   : c35
//  revision  : REVISION 3.0 Wafer C50118W01 2013/12/12;
//  extracted : MCT;
//  doc#      : Eng-327 REV 5.0
//  ----------------------------------------------------------------------
//                        MONTE CARLO CONDITION
//  ----------------------------------------------------------------------
//
// UNSYMMETRIC HV-TRANSISTOR WITH EXTENDED PARASITICS
// PARAMS: NRD NRS AD AS PD PS AW PW (SEE NETLIST FORMAT DOC.)
// NMOS: N-Well Diode
// PMOS: P-Well Diode + PSUB+Diode
//  ----------------------------------------------------------------------
inline subckt modpd30m ( d g s b psub )
// Parameters: w l nrd nrs ad as pd ps
parameters w=1.0e-6 l=1.0e-6 nrd=0.0 nrs=0.0 ad=0.0 as=0.0 pd=0.0 ps=0.0 mult=1 dtemp=0
+ isoVoltage=50
+ dvthmat=(mv_modpd30m)*(1.73e-08/sqrt(l*w*mult)) dumat=(mu_modpd30m)*(6.15e-09/sqrt(l*w*mult))
if (modpd30m==1){
modpd30m ( d g s b ) mosinsub w=w l=l nrd=0 nrs=8.0000e-07/w ad=0 as=as pd=0 ps=ps
xpd ( d b ) modpd30mpd area=w*3.7e-06 perimeter=3.7e-06*2*mult
xnwd ( psub b ) modpd30mnwd area=(w+1e-06*23.6)*(l+1e-06*8.25) perimeter=4*(l+1e-06*8.25)+(w+1e-06*23.6)
}else
modpd30m ( d s ) resistor r=1e30
notvalid paramtest errorif=(modpd30m==0) \
message="
***************************************************
*
* pmosd30m is not valid in selected process option.
*
***************************************************"
//
model mosinsub hisim_hv version=1.230e+00 type=p \
 corsrd=3.0000e+00  coovlp=1.0000e+00 coovlps=1.0000e+00 \
 coisub=0.0000e+00  coiigs=0.0000e+00  cogidl=0.0000e+00 \
 coisti=0.0000e+00  coadov=1.0000e+00   conqs=0.0000e+00 \
   corg=0.0000e+00 corbnet=0.0000e+00 coflick=1.0000e+00 \
cothrml=1.0000e+00   coign=0.0000e+00  coiprv=1 \
  codfm=0.0000e+00 coselfheat=1.0000e+00   cosym=0.0000e+00  \
cosubnode=0.0000e+00  cotemp=0.0000e+00 coldrift=1.0000e+00 \
coqovsm=1.0000e+00  shemax=5.0000e+02  copprv=1.0000e+00
***************************************************************************
*                             Extension to LDMOS                          *
***************************************************************************
+loverld=loverld17   lover=4.9860e-08 ldrift1=1.0000e-06 \
ldrift2=1.0000e-06  novers=1.8290e+17   nover=2.0600e+17
***************************************************************************
*                                   Charges                               *
***************************************************************************
+     xl=0.0000e+00      xw=5.3321e-11     xld=0.0000e+00 \
  xldld=-3.000e-07     xwd=1.6634e-06    xwdc=0.0000e+00   xwdld=0.0000e+00 \
     ll=0.0000e+00     lld=0.0000e+00     lln=0.0000e+00      wl=0.0000e+00 \
    wld=0.0000e+00     wln=0.0000e+00      vfbc=vfbc17+dvthmat \
    vbi=1.1000e+00      tox=tox17    ddltmax=2.4843e+00 \
ddltslp=0.0000e+00 ddltict=1.0000e+01   kappa=3.9000e+00
***************************************************************************
*                          Threshold Voltage Shift                        *
***************************************************************************
+  parl2=1.0000e-08      sc1=1.2113e+01     sc2=5.0000e-02 \
    sc3=0.0000e+00     sc4=0.0000e+00  pthrou=0.0000e+00 \
     nsubp=nsubp17      lp=1.3447e-07     bs1=0.0000e+00 \
    bs2=9.0000e-01    scp1=1.5395e+00    scp2=1.0000e-01 \
   scp3=0.0000e+00   scp21=0.0000e+00   scp22=0.0000e+00 \
  npext=1.0000e+17   lpext=1.0000e-50
***************************************************************************
*                   Depletion Effect of the Gate Poly-Si                  *
***************************************************************************
+   pgd1=0.0000e+00    pgd2=1.0000e+00    pgd3=8.0000e-01 \
   pgd4=0.0000e+00
***************************************************************************
*                       Quantum Mechanical Effects                        *
***************************************************************************
+   qme1=0.0000e+00    qme2=1.0000e+00    qme3=0.0000e+00
***************************************************************************
*                            Mobility Model                               *
***************************************************************************
+muecb0=1.0000e+02*(1+dumat)     muecb1=7.5427e+01*(1+dumat) mueph0=3.0000e-01 \
mueph1=mueph117*(1+dumat) muephl=muephl17  mueplp=1.0000e+00 \
 muesr0=2.2790e+00      muesr1=8.6146e+15*(1+dumat) muesrl=-1.087e-01 \
 mueslp=1.0000e+00    ndep=1.0000e+00   ndepl=0.0000e+00 \
 ndeplp=1.0000e+00    ninv=5.0000e-01   ninvd=0.0000e+00 \
     bb=1.0000e+00     vmax=6.4148e+06 \
  vover=3.2667e+00 \
 voverp=2.0000e+00
***************************************************************************
*                        Channel Length Modulation                        *
***************************************************************************
+   clm1=5.0000e-01    clm2=4.0000e+00    clm3=1.0000e+00 \
   clm5=1.0000e+00    clm6=0.0000e+00
***************************************************************************
*                          Narrow Channel Effects                         *
***************************************************************************
+    wfc=0.0000e+00   wvth0=-2.159e-01     nsubc=nsubc17 \
 nsubcw=0.0000e+00 nsubcwp=1.0000e+00  nsubp0=0.0000e+00 \
 nsubwp=1.0000e+00  muephw=4.5673e+00  muepwp=1.0000e+00 \
 muesrw=7.8626e-02  mueswp=1.0000e+00  vthsti=0.0000e+00 \
  vdsti=0.0000e+00  scsti1=0.0000e+00  scsti2=0.0000e+00 \
   nsti=1.0000e+17    wsti=0.0000e+00   wstil=0.0000e+00 \
 wstilp=1.0000e+00   wstiw=0.0000e+00  wstiwp=1.0000e+00 \
    wl1=0.0000e+00    wl1p=1.0000e+00     wl2=-1.938e-01 \
   wl2p=1.0000e+00  muephs=-5.777e-01  muepsp=1.0000e+00 \
 vovers=-1.000e-01 voversp=0.0000e+00
***************************************************************************
*                          Source/Drain Diffusion                         *
***************************************************************************
+nsubpsti1=0.0000e+00 nsubpsti2=0.0000e+00 nsubpsti3=1.0000e+00 \
muesti1=0.0000e+00 muesti2=0.0000e+00 muesti3=1.0000e+00 \
  saref=1.0000e-06   sbref=1.0000e-06
***************************************************************************
*                         Temperature Dependencies                        *
***************************************************************************
+    eg0=1.1790e+00  bgtmp1=9.0255e-05  bgtmp2=-2.432e-07 \
 muetmp=1.2226e+00    tnom=2.7000e+01    vtmp=3.6866e-01 \
   egig=0.0000e+00 igtemp2=0.0000e+00 igtemp3=0.0000e+00 \
rdtemp1=3.4836e-04 rdtemp2=2.6548e-06 rdvdtemp1=-5.189e-04 \
rdvdtemp2=9.7855e-07
***************************************************************************
*                                Resistances                              *
***************************************************************************
    +rd=rd17      rs=0.0000e+00     rsh=0.0000e+00 \
   rshg=0.0000e+00    rbpb=5.0000e+01    rbpd=5.0000e+01 \
   rbps=5.0000e+01 \
 rdvg11=6.4018e+00  rdvg12=1.6108e+01     rdvd=rdvd17 \
   rdvb=7.4912e-02     rds=-7.748e-01    rdsp=1.0000e+00 \
  rdvdl=0.0000e+00   rdvds=-4.921e-01  rdvdsp=1.0000e+00 \
 rdov11=0.0000e+00  rdov12=1.0000e+00  rdov13=1.0000e+00 \
 rdslp1=0.0000e+00    rd20=0.0000e+00    rd21=1.0000e+00 \
   rd22=-1.312e-01   rd22d=0.0000e+00     rd23=3.7023e-01 \
  rd23l=5.6859e-01  rd23lp=1.0000e+00   rd23s=-1.675e+00 \
 rd23sp=1.0000e+00    rd24=0.0000e+00    rd25=0.0000e+00 \
  gbmin=1.0000e-12
***************************************************************************
*                                Capacitances                             *
***************************************************************************
+    xqy=0.0000e+00    xqy1=0.0000e+00    xqy2=2.0000e+00 \
vfbover=-1.000e+00   qovsm=2.0000e-01   ovslp=2.0000e-08 \
  ovmag=5.0000e+02    cgso=cgso17    cgdo=cgdo17 \
   cgbo=1.1000e-10   tpoly=2.0000e-07
***************************************************************************
*                              Leakage Currents                           *
***************************************************************************
+   sub1=5.0000e-02   sub1l=2.5000e-03  sub1lp=1.0000e+00 \
   sub2=3.0048e+01   sub2l=2.0000e-06    svds=8.0000e-01 \
    slg=3.0000e-08    slgl=0.0000e+00   slglp=1.0000e+00 \
   svbs=5.0000e-01   svbsl=0.0000e+00  svbslp=1.0000e+00 \
   svgs=8.0000e-01   svgsl=0.0000e+00  svgslp=1.0000e+00 \
  svgsw=0.0000e+00  svgswp=1.0000e+00   ibpc1=0.0000e+00 \
  ibpc2=0.0000e+00  subld1=0.0000e+00  subld2=0.0000e+00 \
 gleak1=5.0000e+01  gleak2=1.0000e+07  gleak3=6.0000e-02 \
 gleak4=4.0000e+00  gleak5=7.5000e+03  gleak6=2.5000e-01 \
 gleak7=1.0000e-06   glkb1=5.0000e-16   glkb2=1.0000e+00 \
  glkb3=0.0000e+00  glksd1=1.0000e-15  glksd2=1.0000e-02 \
 glksd3=-1.000e-02 glpart1=5.0000e-01     fn1=0.0000e+00 \
    fn2=0.0000e+00     fn3=0.0000e+00    fvbs=0.0000e+00 \
  gidl1=2.0000e+00   gidl2=3.0000e+07   gidl3=9.0000e-01 \
  gidl4=9.0000e-01   gidl5=2.0000e-01
***************************************************************************
*                             S/B and D/B Diodes                          *
***************************************************************************
+    js0=3.0890e-07   js0sw=1.1310e-13      nj=1.0000e+00 \
   njsw=1.0000e+00     xti=3.8400e+00    xti2=3.8400e+00 \
   divx=0.0000e+00    cisb=0.0000e+00     cvb=0.0000e+00 \
  ctemp=0.0000e+00   cisbk=0.0000e+00    cvbk=0.0000e+00 \
     cj=cj17    cjsw=cjsw17   cjswg=3.5000e-10 \
     mj=5.4000e-01    mjsw=4.6000e-01   mjswg=4.6000e-01 \
     pb=1.0200e+00    pbsw=1.0200e+00   pbswg=1.0200e+00 \
 vdiffj=6.0000e-04
***************************************************************************
*                                   Noise                                 *
***************************************************************************
+  nftrp=3.2435e+07   nfalp=1.5485e-18     cit=0.0000e+00 \
  falph=1.0000e+00
***************************************************************************
*                           Non Quasi Static Model                        *
***************************************************************************
+   dly1=1.0000e-10    dly2=7.0000e-01    dly3=8.0000e-07 \
  dlyov=0.0000e+00
***************************************************************************
*                            Self heating Effect                          *
***************************************************************************
+   rth0=5.5684e-01    cth0=1.0000e-07   rth0w=-8.500e+00 \
 rth0wp=1.0000e+00  rth0nf=0.0000e+00
***************************************************************************
*                                   DFM                                   *
***************************************************************************
+ mphdfm=-3.000e-01
***************************************************************************
*                         Additional Node                                 *
***************************************************************************
+ pzadd0=5.0000e-03  vzadd0=1.0000e-02 \
 rdict1=1.0000e+00  rdict2=0.0000e+00  rdvdlp=1.0000e+00 \
 vbsmin=-1.050e+01  rdslp2=1.0000e+00
***************************************************************************
*                         Additional Node                                 *
***************************************************************************
+ rdvsub=3.0000e-01 rdvdsub=1.0000e+00  ddrift=1.0000e-06 \
 vbisub=7.0000e-01 nsubsub=1.0000e+15
ends modpd30m
//

inline subckt modpd30mpd ( a c )
parameters area=1.0e-12 perimeter=1.0e-6
modpd30mpd ( a c ) diodeinsub area=area perim=perimeter region=off
model diodeinsub diode level=1 dskip=no \
  is=6.1140e-07          isw=2.4910e-13 \
   n=1.0400e+00           ns=1.0400e+00 \
minr=0.100e+00          imax=(1.000e+00/area) \
 cj0=1.2340e-03           m=6.2660e-01 \
  vj=1.0200e+00           tt=0.000e+00 \
cjsw=2.8230e-10         mjsw=4.8760e-01 \
vjsw=1.0200e+00           fc=0.000e+00 \
  af=1.000e+00             kf=0.000e+00 \
 xti=2.7630e+00
ends modpd30mpd
//

inline subckt modpd30mnwd ( a c )
parameters area=1.0e-12 perimeter=1.0e-6
modpd30mnwd ( a c ) diodeinsub area=area perim=perimeter region=off
model diodeinsub diode level=1 dskip=no \
  is=7.101e-06          isw=5.386e-12 \
   n=1.000e+00      ns=1.000e+00 \
minr=0.100e+00    imax=(1.000e+00/area) \
 cj0=3.850e-04           m=2.982e-01 \
  vj=5.300e-01          vjsw=5.300e-01 \
  fc=0.000e+00        tt=0.000e+00 \
cjsw=0.000e+00       mjsw=4.401e-01 \
  af=1.000e+00     kf=0.000e+00 \
 xti=-3.138e+00
ends modpd30mnwd

// ----------------------------------------------------------------------
// Owner: austriamicrosystems
// HIT-Kit: Digital
// ************************ SIMULATION PARAMETERS ************************
//  ----------------------------------------------------------------------
//  format    : Spectre (Spectre Direct)
//  model     : MOS HiSIM_HV
//  process   : c35
//  revision  : REVISION 1.0 Wafer C50118W01 2013/12/12;
//  extracted : MCT;
//  doc#      : Eng-327 REV 5.0
//  ----------------------------------------------------------------------
//                        MONTE CARLO CONDITION
//  ----------------------------------------------------------------------
//
// UNSYMMETRIC HV-TRANSISTOR WITH EXTENDED PARASITICS
// PARAMS: NRD NRS AD AS PD PS AW PW (SEE NETLIST FORMAT DOC.)
// NMOS: N-Well Diode
// PMOS: P-Well Diode + PSUB+Diode
//  ----------------------------------------------------------------------
inline subckt modp30m ( d g s b psub )
// Parameters: w l nrd nrs ad as pd ps
parameters w=1.0e-6 l=1.0e-6 nrd=0.0 nrs=0.0 ad=0.0 as=0.0 pd=0.0 ps=0.0 mult=1 dtemp=0
+ isoVoltage=50
+ dvthmat=(mv_modp30m)*(1.73e-08/sqrt(l*w*mult)) dumat=(mu_modp30m)*(6.15e-09/sqrt(l*w*mult))
if (modp30m==1){
modp30m ( d g s b ) mosinsub w=w l=l nrd=0 nrs=8.0000e-07/w ad=0 as=as pd=0 ps=ps
xpd ( d b ) modp30mpd area=w*3.7e-06 perimeter=3.7e-06*2*mult
xnwd ( psub b ) modp30mnwd area=(w+1e-06*23.6)*(l+1e-06*8.25) perimeter=4*(l+1e-06*8.25)+(w+1e-06*23.6)
}else
modp30m ( d s ) resistor r=1e30
notvalid paramtest errorif=(modp30m==0) \
message="
***************************************************
*
* pmosd30m is not valid in selected process option.
*
***************************************************"
//
model mosinsub hisim_hv version=1.230e+00 type=p \
 corsrd=3.0000e+00  coovlp=1.0000e+00 coovlps=1.0000e+00 \
 coisub=0.0000e+00  coiigs=0.0000e+00  cogidl=0.0000e+00 \
 coisti=0.0000e+00  coadov=1.0000e+00   conqs=0.0000e+00 \
   corg=0.0000e+00 corbnet=0.0000e+00 coflick=1.0000e+00 \
cothrml=1.0000e+00   coign=0.0000e+00  coiprv=1 \
  codfm=0.0000e+00 coselfheat=1.0000e+00   cosym=0.0000e+00  \
cosubnode=0.0000e+00  cotemp=0.0000e+00 coldrift=1.0000e+00 \
coqovsm=1.0000e+00  shemax=5.0000e+02  copprv=1.0000e+00
***************************************************************************
*                             Extension to LDMOS                          *
***************************************************************************
+loverld=loverld18   lover=4.9860e-08 ldrift1=1.0000e-06 \
ldrift2=1.0000e-06  novers=1.8290e+17   nover=2.0600e+17
***************************************************************************
*                                   Charges                               *
***************************************************************************
+     xl=0.0000e+00      xw=5.3321e-11     xld=0.0000e+00 \
  xldld=-3.000e-07     xwd=1.6634e-06    xwdc=0.0000e+00   xwdld=0.0000e+00 \
     ll=0.0000e+00     lld=0.0000e+00     lln=0.0000e+00      wl=0.0000e+00 \
    wld=0.0000e+00     wln=0.0000e+00      vfbc=vfbc18+dvthmat \
    vbi=1.1000e+00      tox=tox18    ddltmax=2.4843e+00 \
ddltslp=0.0000e+00 ddltict=1.0000e+01   kappa=3.9000e+00
***************************************************************************
*                          Threshold Voltage Shift                        *
***************************************************************************
+  parl2=1.0000e-08      sc1=1.2113e+01     sc2=5.0000e-02 \
    sc3=0.0000e+00     sc4=0.0000e+00  pthrou=0.0000e+00 \
     nsubp=nsubp18      lp=1.3447e-07     bs1=0.0000e+00 \
    bs2=9.0000e-01    scp1=1.5395e+00    scp2=1.0000e-01 \
   scp3=0.0000e+00   scp21=0.0000e+00   scp22=0.0000e+00 \
  npext=1.0000e+17   lpext=1.0000e-50
***************************************************************************
*                   Depletion Effect of the Gate Poly-Si                  *
***************************************************************************
+   pgd1=0.0000e+00    pgd2=1.0000e+00    pgd3=8.0000e-01 \
   pgd4=0.0000e+00
***************************************************************************
*                       Quantum Mechanical Effects                        *
***************************************************************************
+   qme1=0.0000e+00    qme2=1.0000e+00    qme3=0.0000e+00
***************************************************************************
*                            Mobility Model                               *
***************************************************************************
+muecb0=1.0000e+02*(1+dumat)     muecb1=7.5427e+01*(1+dumat) mueph0=3.0000e-01 \
mueph1=mueph118*(1+dumat) muephl=muephl18  mueplp=1.0000e+00 \
 muesr0=2.2790e+00      muesr1=8.6146e+15*(1+dumat) muesrl=-1.087e-01 \
 mueslp=1.0000e+00    ndep=1.0000e+00   ndepl=0.0000e+00 \
 ndeplp=1.0000e+00    ninv=5.0000e-01   ninvd=0.0000e+00 \
     bb=1.0000e+00     vmax=6.4148e+06 \
  vover=3.2667e+00 \
 voverp=2.0000e+00
***************************************************************************
*                        Channel Length Modulation                        *
***************************************************************************
+   clm1=5.0000e-01    clm2=4.0000e+00    clm3=1.0000e+00 \
   clm5=1.0000e+00    clm6=0.0000e+00
***************************************************************************
*                          Narrow Channel Effects                         *
***************************************************************************
+    wfc=0.0000e+00   wvth0=-2.159e-01     nsubc=nsubc18 \
 nsubcw=0.0000e+00 nsubcwp=1.0000e+00  nsubp0=0.0000e+00 \
 nsubwp=1.0000e+00  muephw=4.5673e+00  muepwp=1.0000e+00 \
 muesrw=7.8626e-02  mueswp=1.0000e+00  vthsti=0.0000e+00 \
  vdsti=0.0000e+00  scsti1=0.0000e+00  scsti2=0.0000e+00 \
   nsti=1.0000e+17    wsti=0.0000e+00   wstil=0.0000e+00 \
 wstilp=1.0000e+00   wstiw=0.0000e+00  wstiwp=1.0000e+00 \
    wl1=0.0000e+00    wl1p=1.0000e+00     wl2=-1.938e-01 \
   wl2p=1.0000e+00  muephs=-5.777e-01  muepsp=1.0000e+00 \
 vovers=-1.000e-01 voversp=0.0000e+00
***************************************************************************
*                          Source/Drain Diffusion                         *
***************************************************************************
+nsubpsti1=0.0000e+00 nsubpsti2=0.0000e+00 nsubpsti3=1.0000e+00 \
muesti1=0.0000e+00 muesti2=0.0000e+00 muesti3=1.0000e+00 \
  saref=1.0000e-06   sbref=1.0000e-06
***************************************************************************
*                         Temperature Dependencies                        *
***************************************************************************
+    eg0=1.1790e+00  bgtmp1=9.0255e-05  bgtmp2=-2.432e-07 \
 muetmp=1.2226e+00    tnom=2.7000e+01    vtmp=3.6866e-01 \
   egig=0.0000e+00 igtemp2=0.0000e+00 igtemp3=0.0000e+00 \
rdtemp1=3.4836e-04 rdtemp2=2.6548e-06 rdvdtemp1=-5.189e-04 \
rdvdtemp2=9.7855e-07
***************************************************************************
*                                Resistances                              *
***************************************************************************
    +rd=rd18      rs=0.0000e+00     rsh=0.0000e+00 \
   rshg=0.0000e+00    rbpb=5.0000e+01    rbpd=5.0000e+01 \
   rbps=5.0000e+01 \
 rdvg11=6.4018e+00  rdvg12=1.6108e+01     rdvd=rdvd18 \
   rdvb=7.4912e-02     rds=-7.748e-01    rdsp=1.0000e+00 \
  rdvdl=0.0000e+00   rdvds=-4.921e-01  rdvdsp=1.0000e+00 \
 rdov11=0.0000e+00  rdov12=1.0000e+00  rdov13=1.0000e+00 \
 rdslp1=0.0000e+00    rd20=0.0000e+00    rd21=1.0000e+00 \
   rd22=-1.312e-01   rd22d=0.0000e+00     rd23=3.7023e-01 \
  rd23l=5.6859e-01  rd23lp=1.0000e+00   rd23s=-1.675e+00 \
 rd23sp=1.0000e+00    rd24=0.0000e+00    rd25=0.0000e+00 \
  gbmin=1.0000e-12
***************************************************************************
*                                Capacitances                             *
***************************************************************************
+    xqy=0.0000e+00    xqy1=0.0000e+00    xqy2=2.0000e+00 \
vfbover=-1.000e+00   qovsm=2.0000e-01   ovslp=2.0000e-08 \
  ovmag=5.0000e+02    cgso=cgso18    cgdo=cgdo18 \
   cgbo=1.1000e-10   tpoly=2.0000e-07
***************************************************************************
*                              Leakage Currents                           *
***************************************************************************
+   sub1=5.0000e-02   sub1l=2.5000e-03  sub1lp=1.0000e+00 \
   sub2=3.0048e+01   sub2l=2.0000e-06    svds=8.0000e-01 \
    slg=3.0000e-08    slgl=0.0000e+00   slglp=1.0000e+00 \
   svbs=5.0000e-01   svbsl=0.0000e+00  svbslp=1.0000e+00 \
   svgs=8.0000e-01   svgsl=0.0000e+00  svgslp=1.0000e+00 \
  svgsw=0.0000e+00  svgswp=1.0000e+00   ibpc1=0.0000e+00 \
  ibpc2=0.0000e+00  subld1=0.0000e+00  subld2=0.0000e+00 \
 gleak1=5.0000e+01  gleak2=1.0000e+07  gleak3=6.0000e-02 \
 gleak4=4.0000e+00  gleak5=7.5000e+03  gleak6=2.5000e-01 \
 gleak7=1.0000e-06   glkb1=5.0000e-16   glkb2=1.0000e+00 \
  glkb3=0.0000e+00  glksd1=1.0000e-15  glksd2=1.0000e-02 \
 glksd3=-1.000e-02 glpart1=5.0000e-01     fn1=0.0000e+00 \
    fn2=0.0000e+00     fn3=0.0000e+00    fvbs=0.0000e+00 \
  gidl1=2.0000e+00   gidl2=3.0000e+07   gidl3=9.0000e-01 \
  gidl4=9.0000e-01   gidl5=2.0000e-01
***************************************************************************
*                             S/B and D/B Diodes                          *
***************************************************************************
+    js0=3.0890e-07   js0sw=1.1310e-13      nj=1.0000e+00 \
   njsw=1.0000e+00     xti=3.8400e+00    xti2=3.8400e+00 \
   divx=0.0000e+00    cisb=0.0000e+00     cvb=0.0000e+00 \
  ctemp=0.0000e+00   cisbk=0.0000e+00    cvbk=0.0000e+00 \
     cj=cj18    cjsw=cjsw18   cjswg=3.5000e-10 \
     mj=5.4000e-01    mjsw=4.6000e-01   mjswg=4.6000e-01 \
     pb=1.0200e+00    pbsw=1.0200e+00   pbswg=1.0200e+00 \
 vdiffj=6.0000e-04
***************************************************************************
*                                   Noise                                 *
***************************************************************************
+  nftrp=3.2435e+07   nfalp=1.5485e-18     cit=0.0000e+00 \
  falph=1.0000e+00
***************************************************************************
*                           Non Quasi Static Model                        *
***************************************************************************
+   dly1=1.0000e-10    dly2=7.0000e-01    dly3=8.0000e-07 \
  dlyov=0.0000e+00
***************************************************************************
*                            Self heating Effect                          *
***************************************************************************
+   rth0=5.5684e-01    cth0=1.0000e-07   rth0w=-8.500e+00 \
 rth0wp=1.0000e+00  rth0nf=0.0000e+00
***************************************************************************
*                                   DFM                                   *
***************************************************************************
+ mphdfm=-3.000e-01
***************************************************************************
*                         Additional Node                                 *
***************************************************************************
+ pzadd0=5.0000e-03  vzadd0=1.0000e-02 \
 rdict1=1.0000e+00  rdict2=0.0000e+00  rdvdlp=1.0000e+00 \
 vbsmin=-1.050e+01  rdslp2=1.0000e+00
***************************************************************************
*                         Additional Node                                 *
***************************************************************************
+ rdvsub=3.0000e-01 rdvdsub=1.0000e+00  ddrift=1.0000e-06 \
 vbisub=7.0000e-01 nsubsub=1.0000e+15
ends modp30m
//

inline subckt modp30mpd ( a c )
parameters area=1.0e-12 perimeter=1.0e-6
modp30mpd ( a c ) diodeinsub area=area perim=perimeter region=off
model diodeinsub diode level=1 dskip=no \
  is=6.1140e-07          isw=2.4910e-13 \
   n=1.0400e+00           ns=1.0400e+00 \
minr=0.100e+00          imax=(1.000e+00/area) \
 cj0=1.2340e-03           m=6.2660e-01 \
  vj=1.0200e+00           tt=0.000e+00 \
cjsw=2.8230e-10         mjsw=4.8760e-01 \
vjsw=1.0200e+00           fc=0.000e+00 \
  af=1.000e+00             kf=0.000e+00 \
 xti=2.7630e+00
ends modp30mpd
//

inline subckt modp30mnwd ( a c )
parameters area=1.0e-12 perimeter=1.0e-6
modp30mnwd ( a c ) diodeinsub area=area perim=perimeter region=off
model diodeinsub diode level=1 dskip=no \
  is=7.101e-06          isw=5.386e-12 \
   n=1.000e+00      ns=1.000e+00 \
minr=0.100e+00    imax=(1.000e+00/area) \
 cj0=3.850e-04           m=2.982e-01 \
  vj=5.300e-01          vjsw=5.300e-01 \
  fc=0.000e+00        tt=0.000e+00 \
cjsw=0.000e+00       mjsw=4.401e-01 \
  af=1.000e+00     kf=0.000e+00 \
 xti=-3.138e+00
ends modp30mnwd

// ----------------------------------------------------------------------
// Owner: austriamicrosystems
// HIT-Kit: Digital
// ************************ SIMULATION PARAMETERS ************************
//  ----------------------------------------------------------------------
//  format    : Spectre (Spectre Direct)
//  model     : MOS BSIM3v3
//  process   : C35
//  revision  : 1.0;
//  extracted : C18069; 28.08.2011; bse (5866)
//  doc#      : Eng-?? REV_0
//  ----------------------------------------------------------------------
//                        MONTE-CARLO SIMULATION
//
//  ----------------------------------------------------------------------
//
inline subckt nmosw_2n ( d g s b )
parameters w=1.0e-6 l=1.0e-6 nrd=0.0 nrs=0.0 ad=0.0 as=0.0 pd=0.0 ps=0.0 ng=1
+ ws= w
+ ls= l
+ shk=1
+ dvthmat=(mv_nmosw_2n)*(0.67e-08/sqrt(ls*ws*ng)) dumat=(mu_nmosw_2n)*(4.9e-9/sqrt(ls*ws*ng))
//
if (modn==1)
nmosw_2n ( d g s b ) mosinsub w=ws l=ls nrd=8.0000e-07/ws nrs=8.0000e-07/ws ad=ad as=as pd=pd ps=ps m=ng
else
nmosw_2n ( d s ) resistor r=1e30
notvalid paramtest errorif=(modn==0) \
message="
***************************************************
*
* nmos is not valid in selected process option.
*
***************************************************"
model mosinsub bsim3v3 version=3.2400e+00  type=n  capmod=3.0000e+00 \
 mobmod=1.0000e+00  nqsmod=0.0000e+00  noimod=3.0000e+00 \
   vbox=1.000e+03      k1=k119 \
     k2=0.0000e+00      k3=3.0270e-02     k3b=-1.089e-02 \
    nch=npeak19 vth0=4.5000e-01+delvton+dvthmat \
   voff=-7.600e-02    dvt0=2.1160e+01    dvt1=1.0640e+00 \
   dvt2=3.0590e-02    keta=-1.200e-02 \
 pscbe1=1.0000e+30  pscbe2=1.0000e-06 \
 alpha0=1.9040e-06  alpha1=2.5000e+00   beta0=2.0000e+01 \
  dvt0w=2.0000e+00   dvt1w=1.6970e+06   dvt2w=-1.556e-02 \
     ua=-3.981e-10      ub=2.6890e-18      uc=6.9180e-11 \
u0=4.2200e+02+deluon+(4.2200e+02+deluon)*dumat \
   dsub=5.0000e-01    eta0=1.4790e-02    etab=-5.280e-02 \
nfactor=2.6780e-01 \
     em=4.1000e+07    pclm=9.6570e-01 \
  drout=5.0000e-01 \
     a0=2.0840e+00      a1=0.0000e+00      a2=1.0000e+00 \
   pvag=1.3460e-01    vsat=1.0200e+05     ags=3.6080e-01      b0=5.0200e-08      b1=1.0060e-07 \
  delta=2.3500e-03 pdiblcb=3.2150e-01 \
pdiblc1=1.0800e-01 pdiblc2=1.6220e-03 \
     w0=-3.185e-07 \
    dlc=-1.588e-08 \
dwc=-3.263e-01*l+1.5050e-07    dwb=0.0000e+00     dwg=-9.302e-09 \
     ll=1.0680e-13      lw=0.0000e+00     lwl=0.0000e+00 \
    lln=1.0000e+00     lwn=1.0000e+00      wl=2.8610e-13 \
     ww=-1.130e-14     wwl=-9.411e-21     wln=1.0000e+00 \
     wr=1.0000e+00     wwn=1.0000e+00 \
     at=2.5000e+04     ute=-1.700e+00 \
    kt1=-3.100e-01     kt2=-1.720e-02    kt1l=0.0000e+00 \
    ua1=0.0000e+00     ub1=0.0000e+00     uc1=0.0000e+00 \
    prt=3.0000e+01 \
   cgso=cgsdon        cgdo=cgsdon        cgbo=cgbon      \
   cgdl=2.8530e-10    cgsl=2.8530e-10  ckappa=2.6020e+00 \
     cf=0.0000e+00     elm=5.0000e+00 \
  xpart=1.0000e+00     clc=1.0000e-15     cle=6.0000e-01 \
\
   rdsw=1.1390e+03 \
   cdsc=0.0000e+00   cdscb=1.5000e-09   cdscd=0.0000e+00 \
   prwb=-5.000e-02    prwg=1.3340e-02     cit=8.0260e-04 \
tox=7.6700e-09+deltgox \
  ngate=1.0000e+00 \
    nlx=1.7000e-07 \
     xl=0.0000e+00+dell      xw=0.0000e+00+delw \
     af=1.5070e+00      kf=2.1700e-26      ef=1.0000e+00 \
   noia=1.1210e+19  noib=min(5.3360e+04,2.707e+05)   noic=-5.892e-13 \
     rd=0.0000e+00      rs=0.0000e+00     rsh=7.5000e+01+drdiffn \
   minr=1.000e-03 \
    rdc=0.0000e+00     rsc=0.0000e+00 lint=-3.098e-07 \
wint=-8.969e-07   ldif=0.000e+00    hdif=8.0000e-07 \
     xj=3.0000e-07      js=5.1000e-07 \
      n=1.0000e+00 \
  dskip=no          tlev=0           tlevc=0         \
    jsw=6.0000e-13 \
     cj=cj19    cjsw=cjsw19 \
     fc=0.0000e+00    fcsw=0.000e+00 \
     mj=3.4000e-01    mjsw=2.3000e-01 \
     pb=6.9000e-01    pbsw=6.9000e-01     xti=2.0300e+00
ends nmosw_2n

// ----------------------------------------------------------------------

// ----------------------------------------------------------------------
// Owner: austriamicrosystems
// HIT-Kit: Digital
// ************************ SIMULATION PARAMETERS ************************
//  ----------------------------------------------------------------------
//  format    : Spectre (Spectre Direct)
//  model     : MOS BSIM3v3
//  process   : C35
//  revision  : 1.0;
//  extracted : C18069; 28.08.2011; bse (5866)
//  doc#      : Eng-?? REV_0
//  ----------------------------------------------------------------------
//                        MONTE-CARLO SIMULATION
//
//  ----------------------------------------------------------------------
//
inline subckt nmosw_3n ( d g s b )
parameters w=1.0e-6 l=1.0e-6 nrd=0.0 nrs=0.0 ad=0.0 as=0.0 pd=0.0 ps=0.0 ng=1
+ ws= w
+ ls= l
+ shk=1
+ dvthmat=(mv_nmosw_3n)*(0.67e-08/sqrt(ls*ws*ng)) dumat=(mu_nmosw_3n)*(4.9e-9/sqrt(ls*ws*ng))
//
if (modn==1)
nmosw_3n ( d g s b ) mosinsub w=ws l=ls nrd=8.0000e-07/ws nrs=8.0000e-07/ws ad=ad as=as pd=pd ps=ps m=ng
else
nmosw_3n ( d s ) resistor r=1e30
notvalid paramtest errorif=(modn==0) \
message="
***************************************************
*
* nmos is not valid in selected process option.
*
***************************************************"
model mosinsub bsim3v3 version=3.2400e+00  type=n  capmod=3.0000e+00 \
 mobmod=1.0000e+00  nqsmod=0.0000e+00  noimod=3.0000e+00 \
   vbox=1.000e+03      k1=k120 \
     k2=0.0000e+00      k3=3.0270e-02     k3b=-1.089e-02 \
    nch=npeak20 vth0=4.5000e-01+delvton+dvthmat \
   voff=-7.600e-02    dvt0=2.1160e+01    dvt1=1.0640e+00 \
   dvt2=3.0590e-02    keta=-1.200e-02 \
 pscbe1=1.0000e+30  pscbe2=1.0000e-06 \
 alpha0=1.9040e-06  alpha1=2.5000e+00   beta0=2.0000e+01 \
  dvt0w=2.0000e+00   dvt1w=1.6970e+06   dvt2w=-1.556e-02 \
     ua=-3.981e-10      ub=2.6890e-18      uc=6.9180e-11 \
u0=4.2200e+02+deluon+(4.2200e+02+deluon)*dumat \
   dsub=5.0000e-01    eta0=1.4790e-02    etab=-5.280e-02 \
nfactor=2.6780e-01 \
     em=4.1000e+07    pclm=9.6570e-01 \
  drout=5.0000e-01 \
     a0=2.0840e+00      a1=0.0000e+00      a2=1.0000e+00 \
   pvag=1.3460e-01    vsat=1.0200e+05     ags=3.6080e-01      b0=5.0200e-08      b1=1.0060e-07 \
  delta=2.3500e-03 pdiblcb=3.2150e-01 \
pdiblc1=2.3600e-01 pdiblc2=2.4880e-03 \
     w0=-3.185e-07 \
    dlc=-1.588e-08 \
dwc=-3.263e-01*l+1.5050e-07    dwb=0.0000e+00     dwg=-9.302e-09 \
     ll=1.0680e-13      lw=0.0000e+00     lwl=0.0000e+00 \
    lln=1.0000e+00     lwn=1.0000e+00      wl=2.8610e-13 \
     ww=-1.130e-14     wwl=-9.411e-21     wln=1.0000e+00 \
     wr=1.0000e+00     wwn=1.0000e+00 \
     at=2.5000e+04     ute=-1.700e+00 \
    kt1=-3.100e-01     kt2=-1.720e-02    kt1l=0.0000e+00 \
    ua1=0.0000e+00     ub1=0.0000e+00     uc1=0.0000e+00 \
    prt=3.0000e+01 \
   cgso=cgsdon        cgdo=cgsdon        cgbo=cgbon      \
   cgdl=2.8530e-10    cgsl=2.8530e-10  ckappa=2.6020e+00 \
     cf=0.0000e+00     elm=5.0000e+00 \
  xpart=1.0000e+00     clc=1.0000e-15     cle=6.0000e-01 \
\
   rdsw=1.1390e+03 \
   cdsc=0.0000e+00   cdscb=1.5000e-09   cdscd=0.0000e+00 \
   prwb=-1.471e-01    prwg=1.3340e-02     cit=8.0260e-04 \
tox=7.6700e-09+deltgox \
  ngate=1.0000e+00 \
    nlx=1.7000e-07 \
     xl=0.0000e+00+dell      xw=0.0000e+00+delw \
     af=1.5070e+00      kf=2.1700e-26      ef=1.0000e+00 \
   noia=1.1210e+19  noib=min(5.3360e+04,2.707e+05)   noic=-5.892e-13 \
     rd=0.0000e+00      rs=0.0000e+00     rsh=7.5000e+01+drdiffn \
   minr=1.000e-03 \
    rdc=0.0000e+00     rsc=0.0000e+00 lint=-3.098e-07 \
wint=-8.216e-07   ldif=0.000e+00    hdif=8.0000e-07 \
     xj=3.0000e-07      js=5.1000e-07 \
      n=1.0000e+00 \
  dskip=no          tlev=0           tlevc=0         \
    jsw=6.0000e-13 \
     cj=cj20    cjsw=cjsw20 \
     fc=0.0000e+00    fcsw=0.000e+00 \
     mj=3.4000e-01    mjsw=2.3000e-01 \
     pb=6.9000e-01    pbsw=6.9000e-01     xti=2.0300e+00
ends nmosw_3n

// ----------------------------------------------------------------------

// ----------------------------------------------------------------------
// Owner: austriamicrosystems
// HIT-Kit: Digital
// ************************ SIMULATION PARAMETERS ************************
//  ----------------------------------------------------------------------
//  format    : Spectre (Spectre Direct)
//  model     : MOS BSIM3v3
//  process   : C35
//  revision  : 1.0;
//  extracted : C18069; 28.08.2011; bse (5866)
//  doc#      : Eng-?? REV_0
//  ----------------------------------------------------------------------
//                        MONTE-CARLO SIMULATION
//
//  ----------------------------------------------------------------------
//
inline subckt nmosw_4n ( d g s b )
parameters w=1.0e-6 l=1.0e-6 nrd=0.0 nrs=0.0 ad=0.0 as=0.0 pd=0.0 ps=0.0 ng=1
+ ws= w
+ ls= l
+ shk=1
+ dvthmat=(mv_nmosw_4n)*(0.67e-08/sqrt(ls*ws*ng)) dumat=(mu_nmosw_4n)*(4.9e-9/sqrt(ls*ws*ng))
//
if (modn==1)
nmosw_4n ( d g s b ) mosinsub w=ws l=ls nrd=8.0000e-07/ws nrs=8.0000e-07/ws ad=ad as=as pd=pd ps=ps m=ng
else
nmosw_4n ( d s ) resistor r=1e30
notvalid paramtest errorif=(modn==0) \
message="
***************************************************
*
* nmos is not valid in selected process option.
*
***************************************************"
model mosinsub bsim3v3 version=3.2400e+00  type=n  capmod=3.0000e+00 \
 mobmod=1.0000e+00  nqsmod=0.0000e+00  noimod=3.0000e+00 \
   vbox=1.000e+03      k1=k121 \
     k2=0.0000e+00      k3=3.0270e-02     k3b=-1.089e-02 \
    nch=npeak21 vth0=4.5000e-01+delvton+dvthmat \
   voff=-7.600e-02    dvt0=2.1160e+01    dvt1=1.0640e+00 \
   dvt2=3.0590e-02    keta=-1.200e-02 \
 pscbe1=1.0000e+30  pscbe2=1.0000e-06 \
 alpha0=1.9040e-06  alpha1=2.5000e+00   beta0=2.0000e+01 \
  dvt0w=2.0000e+00   dvt1w=1.6970e+06   dvt2w=-1.556e-02 \
     ua=-3.981e-10      ub=2.5120e-18      uc=6.9180e-11 \
u0=4.2200e+02+deluon+(4.2200e+02+deluon)*dumat \
   dsub=5.0000e-01    eta0=1.4790e-02    etab=-5.280e-02 \
nfactor=2.6780e-01 \
     em=4.1000e+07    pclm=9.6570e-01 \
  drout=5.0000e-01 \
     a0=2.0840e+00      a1=0.0000e+00      a2=1.0000e+00 \
   pvag=1.3460e-01    vsat=1.0200e+05     ags=3.1620e-01      b0=5.0200e-08      b1=1.0060e-07 \
  delta=2.3500e-03 pdiblcb=3.2150e-01 \
pdiblc1=8.3400e-01 pdiblc2=2.4880e-03 \
     w0=-3.185e-07 \
    dlc=-1.588e-08 \
dwc=-3.263e-01*l+1.5050e-07    dwb=0.0000e+00     dwg=-9.302e-09 \
     ll=0.0000e+00      lw=0.0000e+00     lwl=0.0000e+00 \
    lln=1.0000e+00     lwn=1.0000e+00      wl=-1.924e-13 \
     ww=0.0000e+00     wwl=0.0000e+00     wln=1.0000e+00 \
     wr=1.0000e+00     wwn=1.0000e+00 \
     at=2.5000e+04     ute=-1.700e+00 \
    kt1=-3.100e-01     kt2=-1.720e-02    kt1l=0.0000e+00 \
    ua1=0.0000e+00     ub1=0.0000e+00     uc1=0.0000e+00 \
    prt=-2.456e+02 \
   cgso=cgsdon        cgdo=cgsdon        cgbo=cgbon      \
   cgdl=2.8530e-10    cgsl=2.8530e-10  ckappa=2.6020e+00 \
     cf=0.0000e+00     elm=5.0000e+00 \
  xpart=1.0000e+00     clc=1.0000e-15     cle=6.0000e-01 \
\
   rdsw=1.1410e+03 \
   cdsc=0.0000e+00   cdscb=1.5000e-09   cdscd=0.0000e+00 \
   prwb=-7.244e-02    prwg=1.1740e-01     cit=8.0260e-04 \
tox=7.6700e-09+deltgox \
  ngate=1.0000e+00 \
    nlx=1.7000e-07 \
     xl=0.0000e+00+dell      xw=0.0000e+00+delw \
     af=1.5070e+00      kf=2.1700e-26      ef=1.0000e+00 \
   noia=1.1210e+19  noib=min(5.3360e+04,2.707e+05)   noic=-5.892e-13 \
     rd=0.0000e+00      rs=0.0000e+00     rsh=7.5000e+01+drdiffn \
   minr=1.000e-03 \
    rdc=0.0000e+00     rsc=0.0000e+00 lint=-1.868e-07 \
wint=-3.544e-07   ldif=0.000e+00    hdif=8.0000e-07 \
     xj=3.0000e-07      js=5.1000e-07 \
      n=1.0000e+00 \
  dskip=no          tlev=0           tlevc=0         \
    jsw=6.0000e-13 \
     cj=cj21    cjsw=cjsw21 \
     fc=0.0000e+00    fcsw=0.000e+00 \
     mj=3.4000e-01    mjsw=2.3000e-01 \
     pb=6.9000e-01    pbsw=6.9000e-01     xti=2.0300e+00
ends nmosw_4n

// ----------------------------------------------------------------------

// ----------------------------------------------------------------------
// Owner: austriamicrosystems
// HIT-Kit: Digital
// ************************ SIMULATION PARAMETERS ************************
//  ----------------------------------------------------------------------
//  format    : Spectre (Spectre Direct)
//  model     : MOS BSIM3v3
//  process   : C35
//  revision  : 1.0;
//  extracted : C18069; 28.08.2011; bse (5866)
//  doc#      : Eng-?? REV_0
//  ----------------------------------------------------------------------
//                        MONTE-CARLO SIMULATION
//
//  ----------------------------------------------------------------------
//
inline subckt nmosmw_2n ( d g s b )
parameters w=1.0e-6 l=1.0e-6 nrd=0.0 nrs=0.0 ad=0.0 as=0.0 pd=0.0 ps=0.0 ng=1
+ ws= w
+ ls= l
+ shk=1
+ dvthmat=(mv_nmosmw_2n)*(1.03e-08/sqrt(ls*ws*ng)) dumat=(mu_nmosmw_2n)*(3.5e-9/sqrt(ls*ws*ng))
//
if (modnm==1)
nmosmw_2n ( d g s b ) mosinsub w=ws l=ls nrd=6.0000e-07/ws nrs=6.0000e-07/ws ad=ad as=as pd=pd ps=ps m=ng
else
nmosmw_2n ( d s ) resistor r=1e30
notvalid paramtest errorif=(modnm==0) \
message="
***************************************************
*
* nmosm is not valid in selected process option.
*
***************************************************"
model mosinsub bsim3v3 version=3.2400e+00  type=n  capmod=3.0000e+00 \
 mobmod=1.0000e+00  nqsmod=0.0000e+00  noimod=3.0000e+00 \
   vbox=1.000e+03      k1=k122 \
     k2=0.0000e+00      k3=-2.500e+00     k3b=-5.640e-02 \
    nch=npeak22 vth0=7.1900e-01+delvtonm+dvthmat \
   voff=-9.684e-02    dvt0=2.0510e+01    dvt1=1.0610e+00 \
   dvt2=2.5970e-02    keta=3.2000e-02 \
 pscbe1=1.0000e+30  pscbe2=1.0000e-06 \
 alpha0=5.5350e-08  alpha1=1.3930e-01   beta0=1.9570e+01 \
  dvt0w=1.0800e+01   dvt1w=3.0990e+06   dvt2w=1.4520e-01 \
     ua=1.4200e-12      ub=1.7380e-18      uc=5.7540e-11 \
u0=5.0600e+02+deluonm+(5.0600e+02+deluonm)*dumat \
   dsub=5.0000e-01    eta0=4.0860e-02    etab=-1.000e-03 \
nfactor=8.6050e-01 \
     em=4.1000e+07    pclm=9.0000e-01 \
  drout=5.0000e-01 \
     a0=1.0000e+00      a1=0.0000e+00      a2=1.0000e+00 \
   pvag=6.0000e-02    vsat=5.3380e+04     ags=1.9140e-01      b0=2.0000e-08      b1=1.0000e-08 \
  delta=1.0000e-02 pdiblcb=9.7980e-01 \
pdiblc1=2.4800e-01 pdiblc2=1.2400e-03 \
     w0=3.3160e-08 \
    dlc=1.3960e-09 \
dwc=-2.884e-01*l+1.4740e-07    dwb=8.6800e-09     dwg=-3.770e-09 \
     ll=7.4510e-14      lw=0.0000e+00     lwl=0.0000e+00 \
    lln=1.0000e+00     lwn=1.0000e+00      wl=-3.626e-13 \
     ww=-1.514e-14     wwl=-1.321e-20     wln=1.0000e+00 \
     wr=1.0000e+00     wwn=1.0000e+00 \
     at=3.3000e+04     ute=-1.720e+00 \
    kt1=-4.180e-01     kt2=-4.560e-02    kt1l=0.0000e+00 \
    ua1=0.0000e+00     ub1=0.0000e+00     uc1=0.0000e+00 \
    prt=0.0000e+00 \
   cgso=cgsdonm        cgdo=cgsdonm        cgbo=cgbonm      \
   cgdl=1.0000e-10    cgsl=1.0000e-10  ckappa=2.9570e+00 \
     cf=0.0000e+00     elm=5.0000e+00 \
  xpart=1.0000e+00     clc=1.0000e-15     cle=6.0000e-01 \
\
   rdsw=3.0420e+03 \
   cdsc=0.0000e+00   cdscb=2.0000e-03   cdscd=0.0000e+00 \
   prwb=5.0000e-02    prwg=4.3480e-03     cit=0.0000e+00 \
tox=1.5000e-08+deltgoxm \
  ngate=1.0000e+00 \
    nlx=1.5690e-07 \
     xl=0.0000e+00+dellm      xw=0.0000e+00+delwm \
     af=1.6290e+00      kf=9.1800e-26      ef=1.0000e+00 \
   noia=2.2450e+19  noib=min(1.1680e+05,5.463e+05)   noic=-1.680e-12 \
     rd=0.0000e+00      rs=0.0000e+00     rsh=7.9000e+01+drdiffn \
   minr=1.000e-03 \
    rdc=0.0000e+00     rsc=0.0000e+00 lint=-3.093e-07 \
wint=-8.560e-07   ldif=0.000e+00    hdif=6.0000e-07 \
     xj=3.0000e-07      js=5.1000e-07 \
      n=1.0000e+00 \
  dskip=no          tlev=0           tlevc=0         \
    jsw=6.0000e-13 \
     cj=cj22    cjsw=cjsw22 \
     fc=0.0000e+00    fcsw=0.000e+00 \
     mj=3.4000e-01    mjsw=2.3000e-01 \
     pb=6.9000e-01    pbsw=6.9000e-01     xti=2.0300e+00
ends nmosmw_2n

// ----------------------------------------------------------------------

// ----------------------------------------------------------------------
// Owner: austriamicrosystems
// HIT-Kit: Digital
// ************************ SIMULATION PARAMETERS ************************
//  ----------------------------------------------------------------------
//  format    : Spectre (Spectre Direct)
//  model     : MOS BSIM3v3
//  process   : C35
//  revision  : 1.0;
//  extracted : C18069; 28.08.2011; bse (5866)
//  doc#      : Eng-?? REV_0
//  ----------------------------------------------------------------------
//                        MONTE-CARLO SIMULATION
//
//  ----------------------------------------------------------------------
//
inline subckt nmosmw_3n ( d g s b )
parameters w=1.0e-6 l=1.0e-6 nrd=0.0 nrs=0.0 ad=0.0 as=0.0 pd=0.0 ps=0.0 ng=1
+ ws= w
+ ls= l
+ shk=1
+ dvthmat=(mv_nmosmw_3n)*(1.03e-08/sqrt(ls*ws*ng)) dumat=(mu_nmosmw_3n)*(3.5e-9/sqrt(ls*ws*ng))
//
if (modnm==1)
nmosmw_3n ( d g s b ) mosinsub w=ws l=ls nrd=6.0000e-07/ws nrs=6.0000e-07/ws ad=ad as=as pd=pd ps=ps m=ng
else
nmosmw_3n ( d s ) resistor r=1e30
notvalid paramtest errorif=(modnm==0) \
message="
***************************************************
*
* nmosm is not valid in selected process option.
*
***************************************************"
model mosinsub bsim3v3 version=3.2400e+00  type=n  capmod=3.0000e+00 \
 mobmod=1.0000e+00  nqsmod=0.0000e+00  noimod=3.0000e+00 \
   vbox=1.000e+03      k1=k123 \
     k2=0.0000e+00      k3=-2.500e+00     k3b=-5.640e-02 \
    nch=npeak23 vth0=7.1900e-01+delvtonm+dvthmat \
   voff=-9.684e-02    dvt0=2.0510e+01    dvt1=1.0610e+00 \
   dvt2=2.5970e-02    keta=3.2000e-02 \
 pscbe1=1.0000e+30  pscbe2=1.0000e-06 \
 alpha0=5.5350e-08  alpha1=1.3930e-01   beta0=1.9570e+01 \
  dvt0w=1.0800e+01   dvt1w=3.0990e+06   dvt2w=1.4520e-01 \
     ua=1.4200e-12      ub=1.7380e-18      uc=5.7540e-11 \
u0=5.0600e+02+deluonm+(5.0600e+02+deluonm)*dumat \
   dsub=5.0000e-01    eta0=4.0860e-02    etab=-1.000e-03 \
nfactor=8.6050e-01 \
     em=4.1000e+07    pclm=9.0000e-01 \
  drout=5.0000e-01 \
     a0=1.0000e+00      a1=0.0000e+00      a2=1.0000e+00 \
   pvag=6.0000e-02    vsat=6.1710e+04     ags=1.9140e-01      b0=2.0000e-08      b1=1.0000e-08 \
  delta=1.0000e-02 pdiblcb=9.7980e-01 \
pdiblc1=1.4000e-01 pdiblc2=1.3490e-03 \
     w0=3.3160e-08 \
    dlc=1.3960e-09 \
dwc=-2.884e-01*l+1.4740e-07    dwb=8.6800e-09     dwg=-3.770e-09 \
     ll=7.4510e-14      lw=0.0000e+00     lwl=0.0000e+00 \
    lln=1.0000e+00     lwn=1.0000e+00      wl=-1.968e-13 \
     ww=-1.514e-14     wwl=-1.321e-20     wln=1.0000e+00 \
     wr=1.0000e+00     wwn=1.0000e+00 \
     at=3.3000e+04     ute=-1.720e+00 \
    kt1=-4.180e-01     kt2=-4.560e-02    kt1l=0.0000e+00 \
    ua1=0.0000e+00     ub1=0.0000e+00     uc1=0.0000e+00 \
    prt=0.0000e+00 \
   cgso=cgsdonm        cgdo=cgsdonm        cgbo=cgbonm      \
   cgdl=1.0050e-10    cgsl=1.0050e-10  ckappa=2.9570e+00 \
     cf=0.0000e+00     elm=5.0000e+00 \
  xpart=1.0000e+00     clc=1.0000e-15     cle=6.0000e-01 \
\
   rdsw=2.5390e+03 \
   cdsc=0.0000e+00   cdscb=2.0000e-03   cdscd=0.0000e+00 \
   prwb=5.0000e-02    prwg=4.3480e-03     cit=0.0000e+00 \
tox=1.5000e-08+deltgoxm \
  ngate=1.0000e+00 \
    nlx=1.5690e-07 \
     xl=0.0000e+00+dellm      xw=0.0000e+00+delwm \
     af=1.6290e+00      kf=9.1800e-26      ef=1.0000e+00 \
   noia=2.2450e+19  noib=min(1.1680e+05,5.463e+05)   noic=-1.680e-12 \
     rd=0.0000e+00      rs=0.0000e+00     rsh=7.9000e+01+drdiffn \
   minr=1.000e-03 \
    rdc=0.0000e+00     rsc=0.0000e+00 lint=-2.609e-07 \
wint=-6.127e-07   ldif=0.000e+00    hdif=6.0000e-07 \
     xj=3.0000e-07      js=5.1000e-07 \
      n=1.0000e+00 \
  dskip=no          tlev=0           tlevc=0         \
    jsw=6.0000e-13 \
     cj=cj23    cjsw=cjsw23 \
     fc=0.0000e+00    fcsw=0.000e+00 \
     mj=3.4000e-01    mjsw=2.3000e-01 \
     pb=6.9000e-01    pbsw=6.9000e-01     xti=2.0300e+00
ends nmosmw_3n

// ----------------------------------------------------------------------

// ----------------------------------------------------------------------
// Owner: austriamicrosystems
// HIT-Kit: Digital
// ************************ SIMULATION PARAMETERS ************************
//  ----------------------------------------------------------------------
//  format    : Spectre (Spectre Direct)
//  model     : MOS BSIM3v3
//  process   : C35
//  revision  : 1.0;
//  extracted : C18069; 28.08.2011; bse (5866)
//  doc#      : Eng-?? REV_0
//  ----------------------------------------------------------------------
//                        MONTE-CARLO SIMULATION
//
//  ----------------------------------------------------------------------
//
inline subckt nmosmw_4n ( d g s b )
parameters w=1.0e-6 l=1.0e-6 nrd=0.0 nrs=0.0 ad=0.0 as=0.0 pd=0.0 ps=0.0 ng=1
+ ws= w
+ ls= l
+ shk=1
+ dvthmat=(mv_nmosmw_4n)*(1.03e-08/sqrt(ls*ws*ng)) dumat=(mu_nmosmw_4n)*(3.5e-9/sqrt(ls*ws*ng))
//
if (modnm==1)
nmosmw_4n ( d g s b ) mosinsub w=ws l=ls nrd=6.0000e-07/ws nrs=6.0000e-07/ws ad=ad as=as pd=pd ps=ps m=ng
else
nmosmw_4n ( d s ) resistor r=1e30
notvalid paramtest errorif=(modnm==0) \
message="
***************************************************
*
* nmosm is not valid in selected process option.
*
***************************************************"
model mosinsub bsim3v3 version=3.2400e+00  type=n  capmod=3.0000e+00 \
 mobmod=1.0000e+00  nqsmod=0.0000e+00  noimod=3.0000e+00 \
   vbox=1.000e+03      k1=k124 \
     k2=0.0000e+00      k3=-2.500e+00     k3b=-5.640e-02 \
    nch=npeak24 vth0=7.1900e-01+delvtonm+dvthmat \
   voff=-9.684e-02    dvt0=2.0510e+01    dvt1=1.0610e+00 \
   dvt2=2.5970e-02    keta=3.2000e-02 \
 pscbe1=1.0000e+30  pscbe2=1.0000e-06 \
 alpha0=5.5350e-08  alpha1=1.3930e-01   beta0=1.9570e+01 \
  dvt0w=1.0800e+01   dvt1w=3.0990e+06   dvt2w=1.4520e-01 \
     ua=4.5710e-10      ub=1.7380e-18      uc=5.7540e-11 \
u0=5.0600e+02+deluonm+(5.0600e+02+deluonm)*dumat \
   dsub=5.0000e-01    eta0=4.0860e-02    etab=-1.000e-03 \
nfactor=8.6050e-01 \
     em=4.1000e+07    pclm=9.0000e-01 \
  drout=5.0000e-01 \
     a0=1.0000e+00      a1=0.0000e+00      a2=1.0000e+00 \
   pvag=6.0000e-02    vsat=6.3000e+04     ags=1.4990e-01      b0=2.0000e-08      b1=1.0000e-08 \
  delta=1.0000e-02 pdiblcb=9.7980e-01 \
pdiblc1=3.2000e-02 pdiblc2=1.6680e-03 \
     w0=3.3160e-08 \
    dlc=1.3960e-09 \
dwc=-2.884e-01*l+1.4740e-07    dwb=8.6800e-09     dwg=-3.770e-09 \
     ll=6.7850e-14      lw=0.0000e+00     lwl=0.0000e+00 \
    lln=1.0000e+00     lwn=1.0000e+00      wl=-1.989e-13 \
     ww=-1.514e-14     wwl=-1.321e-20     wln=1.0000e+00 \
     wr=1.0000e+00     wwn=1.0000e+00 \
     at=3.3000e+04     ute=-1.720e+00 \
    kt1=-4.180e-01     kt2=-4.560e-02    kt1l=0.0000e+00 \
    ua1=0.0000e+00     ub1=0.0000e+00     uc1=0.0000e+00 \
    prt=0.0000e+00 \
   cgso=cgsdonm        cgdo=cgsdonm        cgbo=cgbonm      \
   cgdl=1.0000e-10    cgsl=1.0000e-10  ckappa=2.9570e+00 \
     cf=0.0000e+00     elm=5.0000e+00 \
  xpart=1.0000e+00     clc=1.0000e-15     cle=6.0000e-01 \
\
   rdsw=2.7670e+03 \
   cdsc=0.0000e+00   cdscb=2.0000e-03   cdscd=0.0000e+00 \
   prwb=2.0000e-02    prwg=1.0000e-02     cit=0.0000e+00 \
tox=1.5000e-08+deltgoxm \
  ngate=1.0000e+00 \
    nlx=1.5690e-07 \
     xl=0.0000e+00+dellm      xw=0.0000e+00+delwm \
     af=1.6290e+00      kf=9.1800e-26      ef=1.0000e+00 \
   noia=2.2450e+19  noib=min(1.1680e+05,5.463e+05)   noic=-1.680e-12 \
     rd=0.0000e+00      rs=0.0000e+00     rsh=7.9000e+01+drdiffn \
   minr=1.000e-03 \
    rdc=0.0000e+00     rsc=0.0000e+00 lint=-2.104e-07 \
wint=-7.006e-07   ldif=0.000e+00    hdif=6.0000e-07 \
     xj=3.0000e-07      js=5.1000e-07 \
      n=1.0000e+00 \
  dskip=no          tlev=0           tlevc=0         \
    jsw=6.0000e-13 \
     cj=cj24    cjsw=cjsw24 \
     fc=0.0000e+00    fcsw=0.000e+00 \
     mj=3.4000e-01    mjsw=2.3000e-01 \
     pb=6.9000e-01    pbsw=6.9000e-01     xti=2.0300e+00
ends nmosmw_4n

// ----------------------------------------------------------------------

// ----------------------------------------------------------------------
// Owner: austriamicrosystems
// HIT-Kit: Digital
// ************************ SIMULATION PARAMETERS ************************
//  ----------------------------------------------------------------------
//  format    : Spectre (Spectre Direct)
//  model     : MOS BSIM3v3
//  process   : C35
//  revision  : 1.0;
//  extracted : C18069; 28.08.2011; bse (5866)
//  doc#      : Eng-?? REV_0
//  ----------------------------------------------------------------------
//                        MONTE-CARLO SIMULATION
//
//  ----------------------------------------------------------------------
//
inline subckt pmosw_2n ( d g s b )
parameters w=1.0e-6 l=1.0e-6 nrd=0.0 nrs=0.0 ad=0.0 as=0.0 pd=0.0 ps=0.0 ng=1
+ ws= w
+ ls= l
+ shk=1
+ dvthmat=(mv_pmosw_2n)*(1.03e-08/sqrt(ls*ws*ng)) dumat=(mu_pmosw_2n)*(4.89e-9/sqrt(ls*ws*ng))
//
if (modp==1)
pmosw_2n ( d g s b ) mosinsub w=ws l=ls nrd=8.0000e-07/ws nrs=8.0000e-07/ws ad=ad as=as pd=pd ps=ps m=ng
else
pmosw_2n ( d s ) resistor r=1e30
notvalid paramtest errorif=(modp==0) \
message="
***************************************************
*
* pmos is not valid in selected process option.
*
***************************************************"
model mosinsub bsim3v3 version=3.2400e+00  type=p  capmod=3.0000e+00 \
 mobmod=1.0000e+00  nqsmod=0.0000e+00  noimod=3.0000e+00 \
   vbox=1.000e+03      k1=k125 \
     k2=0.0000e+00      k3=5.2000e+00     k3b=-1.000e+00 \
    nch=npeak25 vth0=-7.440e-01+delvtop+dvthmat \
   voff=-1.640e-01    dvt0=2.2000e+00    dvt1=6.3470e-01 \
   dvt2=5.3690e-02    keta=-7.600e-03 \
 pscbe1=1.0000e+30  pscbe2=1.0000e-06 \
 alpha0=1.0000e-09  alpha1=1.1750e-02   beta0=2.2870e+01 \
  dvt0w=1.0090e-01   dvt1w=7.3400e+04   dvt2w=-6.310e-03 \
     ua=4.1690e-10      ub=1.9050e-18      uc=-3.631e-11 \
u0=1.7300e+02+deluop+(1.7300e+02+deluop)*dumat \
   dsub=5.0000e-01    eta0=2.4000e-01    etab=-3.917e-03 \
nfactor=1.0000e+00 \
     em=4.1000e+07    pclm=3.3380e+00 \
  drout=5.0000e-01 \
     a0=9.0000e-01      a1=1.4440e-15      a2=5.0780e-01 \
   pvag=1.0000e-03    vsat=6.0900e+04     ags=2.1480e-01      b0=2.1920e-07      b1=0.0000e+00 \
  delta=1.0000e-02 pdiblcb=1.0000e-02 \
pdiblc1=8.9340e+02 pdiblc2=1.8000e-03 \
     w0=-1.500e-07 \
    dlc=-2.929e-08 \
dwc=-3.000e-01*l+1.5000e-07    dwb=-5.244e-09     dwg=-1.100e-08 \
     ll=3.5530e-15      lw=0.0000e+00     lwl=0.0000e+00 \
    lln=1.0000e+00     lwn=1.0000e+00      wl=-1.712e-12 \
     ww=-4.300e-14     wwl=-2.884e-21     wln=1.0000e+00 \
     wr=1.0000e+00     wwn=1.0000e+00 \
     at=3.3000e+04     ute=-1.300e+00 \
    kt1=-4.740e-01     kt2=-5.440e-02    kt1l=-1.600e-08 \
    ua1=0.0000e+00     ub1=-3.802e-19     uc1=0.0000e+00 \
    prt=0.0000e+00 \
   cgso=cgsdop        cgdo=cgsdop        cgbo=cgbop      \
   cgdl=1.3550e-10    cgsl=1.3550e-10  ckappa=1.0000e-01 \
     cf=0.0000e+00     elm=5.0000e+00 \
  xpart=1.0000e+00     clc=1.0000e-15     cle=6.0000e-01 \
\
   rdsw=1.0660e+04 \
   cdsc=1.2000e-02   cdscb=9.0000e-03   cdscd=1.0000e-03 \
   prwb=1.9620e-02    prwg=-3.558e-02     cit=0.0000e+00 \
tox=7.7540e-09+deltgox \
  ngate=0.0000e+00 \
    nlx=3.0770e-08 \
     xl=0.0000e+00+dell      xw=0.0000e+00+delw \
     af=1.4610e+00      kf=1.1910e-26      ef=1.0000e+00 \
   noia=5.2450e+17  noib=min(4.8160e+03,6.074e+04)   noic=8.0360e-13 \
     rd=0.0000e+00      rs=0.0000e+00     rsh=1.2900e+02+drdiffp \
   minr=1.000e-03 \
    rdc=0.0000e+00     rsc=0.0000e+00 lint=-7.965e-07 \
wint=-1.959e-06   ldif=0.000e+00    hdif=8.0000e-07 \
     xj=3.0000e-07      js=2.8000e-07 \
      n=1.0000e+00 \
  dskip=no          tlev=0           tlevc=0         \
    jsw=3.7000e-13 \
     cj=cj25    cjsw=cjsw25 \
     fc=0.0000e+00    fcsw=0.000e+00 \
     mj=5.4000e-01    mjsw=4.6000e-01 \
     pb=1.0200e+00    pbsw=1.0200e+00     xti=1.9730e+00
ends pmosw_2n

// ----------------------------------------------------------------------

// ----------------------------------------------------------------------
// Owner: austriamicrosystems
// HIT-Kit: Digital
// ************************ SIMULATION PARAMETERS ************************
//  ----------------------------------------------------------------------
//  format    : Spectre (Spectre Direct)
//  model     : MOS BSIM3v3
//  process   : C35
//  revision  : 1.0;
//  extracted : C18069; 28.08.2011; bse (5866)
//  doc#      : Eng-?? REV_0
//  ----------------------------------------------------------------------
//                        MONTE-CARLO SIMULATION
//
//  ----------------------------------------------------------------------
//
inline subckt pmosw_3n ( d g s b )
parameters w=1.0e-6 l=1.0e-6 nrd=0.0 nrs=0.0 ad=0.0 as=0.0 pd=0.0 ps=0.0 ng=1
+ ws= w
+ ls= l
+ shk=1
+ dvthmat=(mv_pmosw_3n)*(1.03e-08/sqrt(ls*ws*ng)) dumat=(mu_pmosw_3n)*(4.89e-9/sqrt(ls*ws*ng))
//
if (modp==1)
pmosw_3n ( d g s b ) mosinsub w=ws l=ls nrd=8.0000e-07/ws nrs=8.0000e-07/ws ad=ad as=as pd=pd ps=ps m=ng
else
pmosw_3n ( d s ) resistor r=1e30
notvalid paramtest errorif=(modp==0) \
message="
***************************************************
*
* pmos is not valid in selected process option.
*
***************************************************"
model mosinsub bsim3v3 version=3.2400e+00  type=p  capmod=3.0000e+00 \
 mobmod=1.0000e+00  nqsmod=0.0000e+00  noimod=3.0000e+00 \
   vbox=1.000e+03      k1=k126 \
     k2=0.0000e+00      k3=5.2000e+00     k3b=-1.000e+00 \
    nch=npeak26 vth0=-7.440e-01+delvtop+dvthmat \
   voff=-1.640e-01    dvt0=2.2000e+00    dvt1=6.3470e-01 \
   dvt2=5.3690e-02    keta=-7.600e-03 \
 pscbe1=1.0000e+30  pscbe2=1.0000e-06 \
 alpha0=1.0000e-09  alpha1=1.1750e-02   beta0=2.2870e+01 \
  dvt0w=1.0090e-01   dvt1w=7.3400e+04   dvt2w=-6.310e-03 \
     ua=4.1690e-10      ub=1.9050e-18      uc=-3.631e-11 \
u0=1.7300e+02+deluop+(1.7300e+02+deluop)*dumat \
   dsub=5.0000e-01    eta0=2.4000e-01    etab=-3.917e-03 \
nfactor=1.0000e+00 \
     em=4.1000e+07    pclm=3.5650e+00 \
  drout=5.0000e-01 \
     a0=9.0000e-01      a1=1.4440e-15      a2=5.0780e-01 \
   pvag=4.6400e+00    vsat=1.0000e+05     ags=3.8020e-01      b0=2.1920e-07      b1=0.0000e+00 \
  delta=1.0000e-02 pdiblcb=1.0000e+00 \
pdiblc1=8.3320e+00 pdiblc2=2.0670e-03 \
     w0=-1.500e-07 \
    dlc=-2.929e-08 \
dwc=-3.000e-01*l+1.5000e-07    dwb=-5.244e-09     dwg=-1.100e-08 \
     ll=3.5530e-15      lw=0.0000e+00     lwl=0.0000e+00 \
    lln=1.0000e+00     lwn=1.0000e+00      wl=-5.064e-13 \
     ww=-4.300e-14     wwl=-2.884e-21     wln=1.0000e+00 \
     wr=1.0000e+00     wwn=1.0000e+00 \
     at=3.3000e+04     ute=-1.300e+00 \
    kt1=-4.740e-01     kt2=-5.440e-02    kt1l=-1.600e-08 \
    ua1=0.0000e+00     ub1=-3.802e-19     uc1=0.0000e+00 \
    prt=0.0000e+00 \
   cgso=cgsdop        cgdo=cgsdop        cgbo=cgbop      \
   cgdl=1.3550e-10    cgsl=1.3550e-10  ckappa=1.0000e-01 \
     cf=0.0000e+00     elm=5.0000e+00 \
  xpart=1.0000e+00     clc=1.0000e-15     cle=6.0000e-01 \
\
   rdsw=5.7750e+03 \
   cdsc=1.2000e-02   cdscb=9.0000e-03   cdscd=1.0000e-03 \
   prwb=1.9620e-02    prwg=-1.019e-02     cit=0.0000e+00 \
tox=7.7540e-09+deltgox \
  ngate=0.0000e+00 \
    nlx=3.0770e-08 \
     xl=0.0000e+00+dell      xw=0.0000e+00+delw \
     af=1.4610e+00      kf=1.1910e-26      ef=1.0000e+00 \
   noia=5.2450e+17  noib=min(4.8160e+03,6.074e+04)   noic=8.0360e-13 \
     rd=0.0000e+00      rs=0.0000e+00     rsh=1.2900e+02+drdiffp \
   minr=1.000e-03 \
    rdc=0.0000e+00     rsc=0.0000e+00 lint=-3.275e-07 \
wint=-9.593e-07   ldif=0.000e+00    hdif=8.0000e-07 \
     xj=3.0000e-07      js=2.8000e-07 \
      n=1.0000e+00 \
  dskip=no          tlev=0           tlevc=0         \
    jsw=3.7000e-13 \
     cj=cj26    cjsw=cjsw26 \
     fc=0.0000e+00    fcsw=0.000e+00 \
     mj=5.4000e-01    mjsw=4.6000e-01 \
     pb=1.0200e+00    pbsw=1.0200e+00     xti=1.9730e+00
ends pmosw_3n

// ----------------------------------------------------------------------

// ----------------------------------------------------------------------
// Owner: austriamicrosystems
// HIT-Kit: Digital
// ************************ SIMULATION PARAMETERS ************************
//  ----------------------------------------------------------------------
//  format    : Spectre (Spectre Direct)
//  model     : MOS BSIM3v3
//  process   : C35
//  revision  : 1.0;
//  extracted : C18069; 28.08.2011; bse (5866)
//  doc#      : Eng-?? REV_0
//  ----------------------------------------------------------------------
//                        MONTE-CARLO SIMULATION
//
//  ----------------------------------------------------------------------
//
inline subckt pmosw_4n ( d g s b )
parameters w=1.0e-6 l=1.0e-6 nrd=0.0 nrs=0.0 ad=0.0 as=0.0 pd=0.0 ps=0.0 ng=1
+ ws= w
+ ls= l
+ shk=1
+ dvthmat=(mv_pmosw_4n)*(1.03e-08/sqrt(ls*ws*ng)) dumat=(mu_pmosw_4n)*(4.89e-9/sqrt(ls*ws*ng))
//
if (modp==1)
pmosw_4n ( d g s b ) mosinsub w=ws l=ls nrd=8.0000e-07/ws nrs=8.0000e-07/ws ad=ad as=as pd=pd ps=ps m=ng
else
pmosw_4n ( d s ) resistor r=1e30
notvalid paramtest errorif=(modp==0) \
message="
***************************************************
*
* pmos is not valid in selected process option.
*
***************************************************"
model mosinsub bsim3v3 version=3.2400e+00  type=p  capmod=3.0000e+00 \
 mobmod=1.0000e+00  nqsmod=0.0000e+00  noimod=3.0000e+00 \
   vbox=1.000e+03      k1=k127 \
     k2=0.0000e+00      k3=5.2000e+00     k3b=-1.000e+00 \
    nch=npeak27 vth0=-7.440e-01+delvtop+dvthmat \
   voff=-1.640e-01    dvt0=2.2000e+00    dvt1=6.3470e-01 \
   dvt2=5.3690e-02    keta=-7.600e-03 \
 pscbe1=1.0000e+30  pscbe2=1.0000e-06 \
 alpha0=1.0000e-09  alpha1=1.1750e-02   beta0=2.2870e+01 \
  dvt0w=1.0090e-01   dvt1w=7.3400e+04   dvt2w=-6.310e-03 \
     ua=4.1690e-10      ub=1.9050e-18      uc=-3.631e-11 \
u0=1.7300e+02+deluop+(1.7300e+02+deluop)*dumat \
   dsub=5.0000e-01    eta0=2.4000e-01    etab=-3.917e-03 \
nfactor=1.0000e+00 \
     em=4.1000e+07    pclm=3.5650e+00 \
  drout=5.0000e-01 \
     a0=9.0000e-01      a1=1.4440e-15      a2=5.0780e-01 \
   pvag=4.6400e+00    vsat=1.5480e+05     ags=3.8020e-01      b0=2.1920e-07      b1=0.0000e+00 \
  delta=1.0000e-02 pdiblcb=1.0000e+00 \
pdiblc1=5.6700e+00 pdiblc2=3.0670e-03 \
     w0=-1.500e-07 \
    dlc=-2.929e-08 \
dwc=-3.000e-01*l+1.5000e-07    dwb=-5.244e-09     dwg=-1.100e-08 \
     ll=3.5530e-15      lw=0.0000e+00     lwl=0.0000e+00 \
    lln=1.0000e+00     lwn=1.0000e+00      wl=-5.064e-13 \
     ww=-4.300e-14     wwl=-2.884e-21     wln=1.0000e+00 \
     wr=1.0000e+00     wwn=1.0000e+00 \
     at=3.3000e+04     ute=-1.300e+00 \
    kt1=-4.740e-01     kt2=-5.440e-02    kt1l=-1.600e-08 \
    ua1=0.0000e+00     ub1=-3.802e-19     uc1=0.0000e+00 \
    prt=0.0000e+00 \
   cgso=cgsdop        cgdo=cgsdop        cgbo=cgbop      \
   cgdl=1.3550e-10    cgsl=1.3550e-10  ckappa=1.0000e-01 \
     cf=0.0000e+00     elm=5.0000e+00 \
  xpart=1.0000e+00     clc=1.0000e-15     cle=6.0000e-01 \
\
   rdsw=5.7750e+03 \
   cdsc=1.2000e-02   cdscb=9.0000e-03   cdscd=1.0000e-03 \
   prwb=1.9620e-02    prwg=-7.244e-03     cit=0.0000e+00 \
tox=7.7540e-09+deltgox \
  ngate=0.0000e+00 \
    nlx=3.0770e-08 \
     xl=0.0000e+00+dell      xw=0.0000e+00+delw \
     af=1.4610e+00      kf=1.1910e-26      ef=1.0000e+00 \
   noia=5.2450e+17  noib=min(4.8160e+03,6.074e+04)   noic=8.0360e-13 \
     rd=0.0000e+00      rs=0.0000e+00     rsh=1.2900e+02+drdiffp \
   minr=1.000e-03 \
    rdc=0.0000e+00     rsc=0.0000e+00 lint=-2.996e-07 \
wint=-6.844e-07   ldif=0.000e+00    hdif=8.0000e-07 \
     xj=3.0000e-07      js=2.8000e-07 \
      n=1.0000e+00 \
  dskip=no          tlev=0           tlevc=0         \
    jsw=3.7000e-13 \
     cj=cj27    cjsw=cjsw27 \
     fc=0.0000e+00    fcsw=0.000e+00 \
     mj=5.4000e-01    mjsw=4.6000e-01 \
     pb=1.0200e+00    pbsw=1.0200e+00     xti=1.9730e+00
ends pmosw_4n

// ----------------------------------------------------------------------

// ----------------------------------------------------------------------
// Owner: austriamicrosystems
// HIT-Kit: Digital
// ************************ SIMULATION PARAMETERS ************************
//  ----------------------------------------------------------------------
//  format    : Spectre (Spectre Direct)
//  model     : MOS BSIM3v3
//  process   : C35
//  revision  : 1.0;
//  extracted : C18069; 28.08.2011; bse (5866)
//  doc#      : Eng-?? REV_0
//  ----------------------------------------------------------------------
//                        MONTE-CARLO SIMULATION
//
//  ----------------------------------------------------------------------
//
inline subckt pmosmw_2n ( d g s b )
parameters w=1.0e-6 l=1.0e-6 nrd=0.0 nrs=0.0 ad=0.0 as=0.0 pd=0.0 ps=0.0 ng=1
+ ws= w
+ ls= l
+ shk=1
+ dvthmat=(mv_pmosmw_2n)*(1.5e-08/sqrt(ls*ws*ng)) dumat=(mu_pmosmw_2n)*(4.3e-9/sqrt(ls*ws*ng))
//
if (modpm==1)
pmosmw_2n ( d g s b ) mosinsub w=ws l=ls nrd=6.0000e-07/ws nrs=6.0000e-07/ws ad=ad as=as pd=pd ps=ps m=ng
else
pmosmw_2n ( d s ) resistor r=1e30
notvalid paramtest errorif=(modpm==0) \
message="
***************************************************
*
* pmosm is not valid in selected process option.
*
***************************************************"
model mosinsub bsim3v3 version=3.2400e+00  type=p  capmod=3.0000e+00 \
 mobmod=1.0000e+00  nqsmod=0.0000e+00  noimod=3.0000e+00 \
   vbox=1.000e+03      k1=k128 \
     k2=0.0000e+00      k3=1.8000e+00     k3b=-1.000e+00 \
    nch=npeak28 vth0=-1.055e+00+delvtopm+dvthmat \
   voff=-1.148e-01    dvt0=1.7000e+00    dvt1=4.0100e-01 \
   dvt2=2.0050e-01    keta=2.0800e-02 \
 pscbe1=1.0000e+30  pscbe2=1.0000e-06 \
 alpha0=1.0000e-07  alpha1=3.1620e+00   beta0=4.2260e+01 \
  dvt0w=2.0000e-01   dvt1w=5.0000e+05   dvt2w=-3.200e+00 \
     ua=3.1000e-09      ub=2.2000e-19      uc=-8.318e-11 \
u0=2.2900e+02+deluopm+(2.2900e+02+deluopm)*dumat \
   dsub=5.0000e-01    eta0=1.7900e-03    etab=-2.948e-02 \
nfactor=7.0460e-01 \
     em=4.1000e+07    pclm=4.9580e+00 \
  drout=5.0000e-01 \
     a0=1.0000e+00      a1=6.0520e-05      a2=2.2110e-01 \
   pvag=1.0000e+00    vsat=5.0470e+04     ags=1.4450e-01      b0=1.3800e-07      b1=0.0000e+00 \
  delta=1.0000e-02 pdiblcb=6.0000e-02 \
pdiblc1=2.5900e+04 pdiblc2=2.4430e-03 \
     w0=-1.800e-07 \
    dlc=-1.766e-08 \
dwc=-2.953e-01*l+1.4210e-07    dwb=-4.580e-09     dwg=-6.295e-09 \
     ll=0.0000e+00      lw=0.0000e+00     lwl=0.0000e+00 \
    lln=1.0000e+00     lwn=1.0000e+00      wl=-3.685e-12 \
     ww=-3.900e-14     wwl=-4.467e-21     wln=1.0000e+00 \
     wr=1.0000e+00     wwn=1.0000e+00 \
     at=7.9640e+04     ute=-1.492e+00 \
    kt1=-5.480e-01     kt2=-6.000e-02    kt1l=-2.600e-08 \
    ua1=-2.630e-10     ub1=-3.311e-18     uc1=0.0000e+00 \
    prt=0.0000e+00 \
   cgso=cgsdopm        cgdo=cgsdopm        cgbo=cgbopm      \
   cgdl=1.0770e-10    cgsl=1.0770e-10  ckappa=1.3700e+00 \
     cf=0.0000e+00     elm=5.0000e+00 \
  xpart=1.0000e+00     clc=1.0000e-15     cle=6.0000e-01 \
\
   rdsw=1.0820e+04 \
   cdsc=1.2140e-03   cdscb=2.9450e-04   cdscd=0.0000e+00 \
   prwb=5.0700e-02    prwg=7.0360e-02     cit=5.2590e-05 \
tox=1.5000e-08+deltgoxm \
  ngate=0.0000e+00 \
    nlx=1.2500e-07 \
     xl=0.0000e+00+dellm      xw=0.0000e+00+delwm \
     af=1.6380e+00      kf=3.6250e-26      ef=1.0000e+00 \
   noia=5.8460e+17  noib=min(6.6230e+03,3.454e+04)   noic=7.7590e-13 \
     rd=0.0000e+00      rs=0.0000e+00     rsh=1.3000e+02+drdiffp \
   minr=1.000e-03 \
    rdc=0.0000e+00     rsc=0.0000e+00 lint=-1.646e-06 \
wint=-2.751e-06   ldif=0.000e+00    hdif=6.0000e-07 \
     xj=3.0000e-07      js=2.8000e-07 \
      n=1.0000e+00 \
  dskip=no          tlev=0           tlevc=0         \
    jsw=3.7000e-13 \
     cj=cj28    cjsw=cjsw28 \
     fc=0.0000e+00    fcsw=0.000e+00 \
     mj=5.4000e-01    mjsw=4.6000e-01 \
     pb=1.0200e+00    pbsw=1.0200e+00     xti=1.9700e+00
ends pmosmw_2n

// ----------------------------------------------------------------------

// ----------------------------------------------------------------------
// Owner: austriamicrosystems
// HIT-Kit: Digital
// ************************ SIMULATION PARAMETERS ************************
//  ----------------------------------------------------------------------
//  format    : Spectre (Spectre Direct)
//  model     : MOS BSIM3v3
//  process   : C35
//  revision  : 1.0;
//  extracted : C18069; 28.08.2011; bse (5866)
//  doc#      : Eng-?? REV_0
//  ----------------------------------------------------------------------
//                        MONTE-CARLO SIMULATION
//
//  ----------------------------------------------------------------------
//
inline subckt pmosmw_3n ( d g s b )
parameters w=1.0e-6 l=1.0e-6 nrd=0.0 nrs=0.0 ad=0.0 as=0.0 pd=0.0 ps=0.0 ng=1
+ ws= w
+ ls= l
+ shk=1
+ dvthmat=(mv_pmosmw_3n)*(1.5e-08/sqrt(ls*ws*ng)) dumat=(mu_pmosmw_3n)*(4.3e-9/sqrt(ls*ws*ng))
//
if (modpm==1)
pmosmw_3n ( d g s b ) mosinsub w=ws l=ls nrd=6.0000e-07/ws nrs=6.0000e-07/ws ad=ad as=as pd=pd ps=ps m=ng
else
pmosmw_3n ( d s ) resistor r=1e30
notvalid paramtest errorif=(modpm==0) \
message="
***************************************************
*
* pmosm is not valid in selected process option.
*
***************************************************"
model mosinsub bsim3v3 version=3.2400e+00  type=p  capmod=3.0000e+00 \
 mobmod=1.0000e+00  nqsmod=0.0000e+00  noimod=3.0000e+00 \
   vbox=1.000e+03      k1=k129 \
     k2=0.0000e+00      k3=1.8000e+00     k3b=-1.000e+00 \
    nch=npeak29 vth0=-1.055e+00+delvtopm+dvthmat \
   voff=-1.148e-01    dvt0=1.7000e+00    dvt1=4.0100e-01 \
   dvt2=2.0050e-01    keta=2.0800e-02 \
 pscbe1=1.0000e+30  pscbe2=1.0000e-06 \
 alpha0=1.0000e-07  alpha1=3.1620e+00   beta0=4.2260e+01 \
  dvt0w=2.0000e-01   dvt1w=5.0000e+05   dvt2w=-3.200e+00 \
     ua=3.1000e-09      ub=2.2000e-19      uc=-1.553e-10 \
u0=2.2900e+02+deluopm+(2.2900e+02+deluopm)*dumat \
   dsub=5.0000e-01    eta0=1.7900e-03    etab=-2.948e-02 \
nfactor=7.0460e-01 \
     em=4.1000e+07    pclm=4.9580e+00 \
  drout=5.0000e-01 \
     a0=1.0000e+00      a1=6.0520e-05      a2=2.2110e-01 \
   pvag=-1.500e+00    vsat=4.9050e+04     ags=1.4450e-01      b0=1.3800e-07      b1=0.0000e+00 \
  delta=1.0000e-02 pdiblcb=6.0000e-02 \
pdiblc1=2.6560e+02 pdiblc2=2.6870e-03 \
     w0=-1.800e-07 \
    dlc=-1.766e-08 \
dwc=-2.953e-01*l+1.4210e-07    dwb=-4.580e-09     dwg=-6.295e-09 \
     ll=0.0000e+00      lw=0.0000e+00     lwl=0.0000e+00 \
    lln=1.0000e+00     lwn=1.0000e+00      wl=-2.315e-12 \
     ww=-3.900e-14     wwl=-4.467e-21     wln=1.0000e+00 \
     wr=1.0000e+00     wwn=1.0000e+00 \
     at=7.9640e+04     ute=-1.492e+00 \
    kt1=-5.480e-01     kt2=-6.000e-02    kt1l=-2.600e-08 \
    ua1=-2.630e-10     ub1=-3.311e-18     uc1=0.0000e+00 \
    prt=0.0000e+00 \
   cgso=cgsdopm        cgdo=cgsdopm        cgbo=cgbopm      \
   cgdl=1.0770e-10    cgsl=1.0770e-10  ckappa=1.3700e+00 \
     cf=0.0000e+00     elm=5.0000e+00 \
  xpart=1.0000e+00     clc=1.0000e-15     cle=6.0000e-01 \
\
   rdsw=1.1340e+04 \
   cdsc=1.2140e-03   cdscb=2.9450e-04   cdscd=0.0000e+00 \
   prwb=-5.503e-02    prwg=1.5470e-02     cit=5.2590e-05 \
tox=1.5000e-08+deltgoxm \
  ngate=0.0000e+00 \
    nlx=1.2500e-07 \
     xl=0.0000e+00+dellm      xw=0.0000e+00+delwm \
     af=1.6380e+00      kf=3.6250e-26      ef=1.0000e+00 \
   noia=5.8460e+17  noib=min(6.6230e+03,3.454e+04)   noic=7.7590e-13 \
     rd=0.0000e+00      rs=0.0000e+00     rsh=1.3000e+02+drdiffp \
   minr=1.000e-03 \
    rdc=0.0000e+00     rsc=0.0000e+00 lint=-1.020e-06 \
wint=-1.770e-06   ldif=0.000e+00    hdif=6.0000e-07 \
     xj=3.0000e-07      js=2.8000e-07 \
      n=1.0000e+00 \
  dskip=no          tlev=0           tlevc=0         \
    jsw=3.7000e-13 \
     cj=cj29    cjsw=cjsw29 \
     fc=0.0000e+00    fcsw=0.000e+00 \
     mj=5.4000e-01    mjsw=4.6000e-01 \
     pb=1.0200e+00    pbsw=1.0200e+00     xti=1.9700e+00
ends pmosmw_3n

// ----------------------------------------------------------------------

// ----------------------------------------------------------------------
// Owner: austriamicrosystems
// HIT-Kit: Digital
// ************************ SIMULATION PARAMETERS ************************
//  ----------------------------------------------------------------------
//  format    : Spectre (Spectre Direct)
//  model     : MOS BSIM3v3
//  process   : C35
//  revision  : 1.0;
//  extracted : C18069; 28.08.2011; bse (5866)
//  doc#      : Eng-?? REV_0
//  ----------------------------------------------------------------------
//                        MONTE-CARLO SIMULATION
//
//  ----------------------------------------------------------------------
//
inline subckt pmosmw_4n ( d g s b )
parameters w=1.0e-6 l=1.0e-6 nrd=0.0 nrs=0.0 ad=0.0 as=0.0 pd=0.0 ps=0.0 ng=1
+ ws= w
+ ls= l
+ shk=1
+ dvthmat=(mv_pmosmw_4n)*(1.5e-08/sqrt(ls*ws*ng)) dumat=(mu_pmosmw_4n)*(4.3e-9/sqrt(ls*ws*ng))
//
if (modpm==1)
pmosmw_4n ( d g s b ) mosinsub w=ws l=ls nrd=6.0000e-07/ws nrs=6.0000e-07/ws ad=ad as=as pd=pd ps=ps m=ng
else
pmosmw_4n ( d s ) resistor r=1e30
notvalid paramtest errorif=(modpm==0) \
message="
***************************************************
*
* pmosm is not valid in selected process option.
*
***************************************************"
model mosinsub bsim3v3 version=3.2400e+00  type=p  capmod=3.0000e+00 \
 mobmod=1.0000e+00  nqsmod=0.0000e+00  noimod=3.0000e+00 \
   vbox=1.000e+03      k1=k130 \
     k2=0.0000e+00      k3=1.8000e+00     k3b=-1.000e+00 \
    nch=npeak30 vth0=-1.055e+00+delvtopm+dvthmat \
   voff=-1.148e-01    dvt0=1.7000e+00    dvt1=4.0100e-01 \
   dvt2=2.0050e-01    keta=2.0800e-02 \
 pscbe1=1.0000e+30  pscbe2=1.0000e-06 \
 alpha0=1.0000e-07  alpha1=3.1620e+00   beta0=4.2260e+01 \
  dvt0w=2.0000e-01   dvt1w=5.0000e+05   dvt2w=-3.200e+00 \
     ua=3.1000e-09      ub=2.2000e-19      uc=-8.318e-11 \
u0=2.2900e+02+deluopm+(2.2900e+02+deluopm)*dumat \
   dsub=5.0000e-01    eta0=1.7900e-03    etab=-2.948e-02 \
nfactor=7.0460e-01 \
     em=4.1000e+07    pclm=4.9580e+00 \
  drout=5.0000e-01 \
     a0=1.0000e+00      a1=6.0520e-05      a2=2.2110e-01 \
   pvag=-1.500e+00    vsat=6.7470e+04     ags=1.4450e-01      b0=1.3800e-07      b1=0.0000e+00 \
  delta=1.0000e-02 pdiblcb=6.0000e-02 \
pdiblc1=2.8350e+01 pdiblc2=3.8950e-03 \
     w0=-1.800e-07 \
    dlc=-1.766e-08 \
dwc=-2.953e-01*l+1.4210e-07    dwb=-4.580e-09     dwg=-6.295e-09 \
     ll=0.0000e+00      lw=0.0000e+00     lwl=0.0000e+00 \
    lln=1.0000e+00     lwn=1.0000e+00      wl=-1.534e-12 \
     ww=-3.900e-14     wwl=-4.467e-21     wln=1.0000e+00 \
     wr=1.0000e+00     wwn=1.0000e+00 \
     at=7.9640e+04     ute=-1.492e+00 \
    kt1=-5.480e-01     kt2=-6.000e-02    kt1l=-2.600e-08 \
    ua1=-2.630e-10     ub1=-3.311e-18     uc1=0.0000e+00 \
    prt=0.0000e+00 \
   cgso=cgsdopm        cgdo=cgsdopm        cgbo=cgbopm      \
   cgdl=1.0770e-10    cgsl=1.0770e-10  ckappa=1.3700e+00 \
     cf=0.0000e+00     elm=5.0000e+00 \
  xpart=1.0000e+00     clc=1.0000e-15     cle=6.0000e-01 \
\
   rdsw=6.6990e+03 \
   cdsc=1.2140e-03   cdscb=2.9450e-04   cdscd=0.0000e+00 \
   prwb=5.0700e-02    prwg=7.7360e-02     cit=5.2590e-05 \
tox=1.5000e-08+deltgoxm \
  ngate=0.0000e+00 \
    nlx=1.2500e-07 \
     xl=0.0000e+00+dellm      xw=0.0000e+00+delwm \
     af=1.6380e+00      kf=3.6250e-26      ef=1.0000e+00 \
   noia=5.8460e+17  noib=min(6.6230e+03,3.454e+04)   noic=7.7590e-13 \
     rd=0.0000e+00      rs=0.0000e+00     rsh=1.3000e+02+drdiffp \
   minr=1.000e-03 \
    rdc=0.0000e+00     rsc=0.0000e+00 lint=-7.278e-07 \
wint=-1.000e-06   ldif=0.000e+00    hdif=6.0000e-07 \
     xj=3.0000e-07      js=2.8000e-07 \
      n=1.0000e+00 \
  dskip=no          tlev=0           tlevc=0         \
    jsw=3.7000e-13 \
     cj=cj30    cjsw=cjsw30 \
     fc=0.0000e+00    fcsw=0.000e+00 \
     mj=5.4000e-01    mjsw=4.6000e-01 \
     pb=1.0200e+00    pbsw=1.0200e+00     xti=1.9700e+00
ends pmosmw_4n

// ----------------------------------------------------------------------

// ----------------------------------------------------------------------
// Owner: austriamicrosystems
// HIT-Kit: Digital
//************************ SIMULATION PARAMETERS ************************
// ----------------------------------------------------------------------
// format    : Spectre
// model     : MODNRF
// process   : CS ADFI
// revision  : 3.1;
// extracted : CSD C64330.04e3; 2002-09; kmo(5966)
// doc#      : ENG-188 REV_5
// ----------------------------------------------------------------------
//                       MONTE-CARLO SIMULATION
// ----------------------------------------------------------------------
//
//  RF CMOS TRANSISTOR MODEL
//
//-----------------------------------------------------------------------
inline subckt modnrf ( d g s b )
parameters w=1.0e-6 l=1.0e-6 nrd=0.0 nrs=0.0 ad=0.0 as=0.0 pd=0.0 ps=0.0 ng=1
+ mmvth_modnrf=0.0 mmu0_modnrf=0.0
+ dvthmat=(mv_modnrf53+mmvth_modnrf)*(0.67e-08/sqrt(l*w*ng)) dumat=(mu_modnrf53+mmu0_modnrf)*(4.9e-9/sqrt(l*w*ng))
// //
if (modnrf==1){
// --------- Gate network ------------------------------
lg  (g 20 ) inductor l=1.000e-15
rg  (20 21 ) resistor r=((6.895e-04/w+4.758e+01 )/ng+(3.726e+05*w+2.740e+00)) isnoisy=yes
//
// --------- Drain network -----------------------------
ldrain ( d 13 ) inductor l=1.000e-15
rdrain ( 13 11 ) resistor r=(3.320e-04/(w*ng)+1.669e-01) isnoisy=yes
//
// --------- Source network -----------------------------
lsource ( s 33 ) inductor l=1.000e-15
rsource ( 33 31 ) resistor r=(3.320e-04/(w*ng)+1.669e-01) isnoisy=yes
//
// --------- Substrate network -------------------------
// Diodes are for n-type or p-type MOS transistors
//
djdb  ( 12 11 ) bulk_diode area=ad*ng perim=pd*ng
djsb  ( 32 31 ) bulk_diode area=as*ng perim=ps*ng
//
rsub1 ( 12 b ) resistor r=((0.000e+00/w+0.000e+00)/ng+(9.524e+06*w+(4.156e+01))) isnoisy=yes
rsub2 ( 32 b ) resistor r=((0.000e+00/w+0.000e+00)/ng+(9.524e+06*w+(4.156e+01))) isnoisy=yes
//
// --------- Ideal mos transistor ----------------------
modnrf ( 11 21 31 b ) mosinsub l=l w=w*ng ad=0.0 as=0.0 pd=0.0 ps=0.0 nrd=0 nrs=0
}else
modnrf ( d s ) resistor r=1e30
notvalid paramtest errorif=(modnrf==0) \
message="
***************************************************
*
* nmosrf is not valid in selected process option.
*
***************************************************"
// Intrinsic MOS transistor
model mosinsub bsim3v3 version=3.1 type=n  capmod=2.0000e+00 \
 mobmod=1.0000e+00  nqsmod=0.0000e+00  noimod=3 \
   vbox=1.000e+03      k1=6.1580e-01 \
     k2=1.8434e-04      k3=-1.715e+00     k3b=6.3250e-01 \
    nch=npeak31 vth0=4.6550e-01+delvton+dvthmat \
   voff=-5.719e-02    dvt0=2.2270e+01    dvt1=1.0510e+00 \
   dvt2=3.3930e-03    keta=-6.207e-04 \
 pscbe1=2.7560e+08  pscbe2=9.6450e-06 \
 alpha0=0.0000e+00   beta0=3.0000e+01 \
  dvt0w=0.0000e+00   dvt1w=0.0000e+00   dvt2w=0.0000e+00 \
     ua=1.0000e-12      ub=4.8510e-18      uc=5.7560e-11 \
u0=6.2680e+02+deluon+(6.2680e+02+deluon)*dumat \
   dsub=5.0000e-01    eta0=3.0850e-02    etab=-3.947e-02 \
nfactor=1.1190e-01 \
     em=4.1000e+07    pclm=1.5270e+00 \
  drout=5.0000e-01 \
     a0=2.2080e+00      a1=0.0000e+00      a2=1.0000e+00 \
   pvag=0.0000e+00    vsat=7.5800e+04     ags=2.4900e-01      b0=-1.765e-08      b1=0.0000e+00 \
  delta=1.0000e-02 pdiblcb=2.5830e-01 \
pdiblc1=1.0760e-01 pdiblc2=1.4530e-03 \
     w0=1.1840e-07 \
    dlc=6.6050e-08 \
    dwc=2.6760e-08     dwb=0.0000e+00     dwg=0.0000e+00 \
     ll=0.000e+00      lw=0.000e+00     lwl=0.000e+00 \
    lln=1.000e+00     lwn=1.000e+00      wl=0.0000e+00 \
     ww=0.0000e+00     wwl=0.0000e+00     wln=1.0000e+00 \
     wr=1.0000e+00     wwn=1.0000e+00 \
     at=3.3000e+04     ute=-1.800e+00 \
    kt1=-3.302e-01     kt2=2.2000e-02    kt1l=0.0000e+00 \
    ua1=0.0000e+00     ub1=0.0000e+00     uc1=0.0000e+00 \
    prt=0.0000e+00 \
   cgso=cgsdon        cgdo=cgsdon        cgbo=cgbon      \
   cgdl=1.0680e-10    cgsl=1.0680e-10  ckappa=6.0000e-01 \
     cf=0.0000e+00     elm=5.0000e+00 \
  xpart=1.0000e+00     clc=1.0000e-15     cle=6.0000e-01 \
\
   rdsw=0.0000e+00 \
   cdsc=0.0000e+00   cdscb=0.0000e+00   cdscd=8.4480e-05 \
   prwb=0.0000e+00    prwg=0.0000e+00     cit=1.0000e-03 \
tox=7.7000e-09+deltgox \
  ngate=0.0000e+00 \
    nlx=1.9180e-07 \
     xl=0.0000e+00+dell      xw=0.0000e+00+delw \
     af=1.5070e+00      kf=2.1700e-26      ef=1.0000e+00 \
   noia=1.1210e+19  noib=min(5.3360e+04,2.707e+05)   noic=-5.892e-13 \
     rd=0.0000e+00      rs=0.0000e+00     rsh=8.2000e+01+drdiffn \
   minr=1.000e-03 \
    rdc=0.0000e+00     rsc=0.0000e+00 lint=8.2850e-09 \
wint=2.6760e-08   ldif=0.000e+00    hdif=6.0000e-07 \
     xj=3.0000e-07      js=5.1000e-07 \
      n=1.0000e+00 \
  dskip=no          tlev=0           tlevc=0         \
    jsw=0.0000e+00 \
     cj=0.0000e+00    cjsw=0.0000e+00 \
     fc=0.0000e+00    fcsw=0.000e+00 \
     mj=3.1000e-01    mjsw=1.9000e-01 \
     pb=6.9000e-01    pbsw=6.9000e-01
// Bulk Diode Model
model bulk_diode diode level=1 dskip=no \
     is=5.100e-07      isw=0.600e-12       n=1.0000000       ns=1.0000000   \
    cjo=1.580e-03       m=3.100e-01 \
    cjsw=0.000e+00       mjsw=2.011E-01 \
     fc=0.000e+00      tt=0.000e+00      vj=6.900e-01      vjsw=6.672E-01  \
     kf=0.000e+00      eg=1.11e+00     xti=2.026e+00      af=1.000e+00
ends modnrf
// ----------------------------------------------------------------------
// ----------------------------------------------------------------------
// Owner: austriamicrosystems
// HIT-Kit: Digital
//************************ SIMULATION PARAMETERS ************************
// ----------------------------------------------------------------------
// format    : Spectre
// model     : MODPRF
// process   : C/B/S 35
// revision  : 3.1;
// extracted : C35B3 B11634.L1 04PA3; 2002-09; kmo(5966)
// doc#      : ENG-188 REV_5
// ----------------------------------------------------------------------
//                       MONTE-CARLO SIMULATION
// ----------------------------------------------------------------------
//
//  RF CMOS TRANSISTOR MODEL
//
//-----------------------------------------------------------------------
inline subckt modprf ( d g s b )
parameters w=1.0e-6 l=1.0e-6 nrd=0.0 nrs=0.0 ad=0.0 as=0.0 pd=0.0 ps=0.0 ng=1
+ mmvth_modprf=0.0 mmu0_modprf=0.0
+ dvthmat=(mv_modprf53+mmvth_modprf)*(1.03e-08/sqrt(l*w*ng)) dumat=(mu_modprf53+mmu0_modprf)*(7.1e-9/sqrt(l*w*ng))
// //
if (modprf==1){
// --------- Gate network ------------------------------
lg  (g 20 ) inductor l=1.000e-15
rg  (20 21 ) resistor r=((-5.800e-04/w+2.884e+02 )/ng+(-5.394e+05*w+1.596e+00)) isnoisy=yes
//
// --------- Drain network -----------------------------
ldrain ( d 13 ) inductor l=1.000e-15
rdrain ( 13 11 ) resistor r=(8.051e-04/(w*ng)+1.731e+00) isnoisy=yes
//
// --------- Source network -----------------------------
lsource ( s 33 ) inductor l=1.000e-15
rsource ( 33 31 ) resistor r=(8.051e-04/(w*ng)+1.731e+00) isnoisy=yes
//
// --------- Substrate network -------------------------
// Diodes are for n-type or p-type MOS transistors
//
djdb  ( 11 12 ) bulk_diode area=ad*ng perim=pd*ng
djsb  ( 31 32 ) bulk_diode area=as*ng perim=ps*ng
//
rsub1 ( 12 b ) resistor r=((1.064e-04/w+1.682e+02)/ng+(1.724e+06*w+(-2.292e+00))) isnoisy=yes
rsub2 ( 32 b ) resistor r=((1.064e-04/w+1.682e+02)/ng+(1.724e+06*w+(-2.292e+00))) isnoisy=yes
//
// --------- Ideal mos transistor ----------------------
modprf ( 11 21 31 b ) mosinsub l=l w=w*ng ad=0.0 as=0.0 pd=0.0 ps=0.0 nrd=0 nrs=0
}else
modprf ( d s ) resistor r=1e30
notvalid paramtest errorif=(modprf==0) \
message="
***************************************************
*
* pmosrf is not valid in selected process option.
*
***************************************************"
// Intrinsic MOS transistor
model mosinsub bsim3v3 version=3.1 type=p  capmod=2.0000e+00 \
 mobmod=1.0000e+00  nqsmod=0.0000e+00  noimod=3 \
   vbox=1.000e+03      k1=9.3231e-03 \
     k2=1.2588e-01      k3=1.1030e+01     k3b=-7.580e-01 \
    nch=npeak32 vth0=-7.359e-01+delvtop+dvthmat \
   voff=-1.170e-01    dvt0=1.6500e+00    dvt1=3.8680e-01 \
   dvt2=1.6590e-02    keta=-1.440e-02 \
 pscbe1=5.0000e+09  pscbe2=1.0000e-04 \
 alpha0=0.0000e+00   beta0=3.0000e+01 \
  dvt0w=1.8790e-01   dvt1w=7.3350e+04   dvt2w=-6.312e-03 \
     ua=5.3940e-10      ub=3.9760e-19      uc=1.0000e-20 \
u0=1.3230e+02+deluop+(1.3230e+02+deluop)*dumat \
   dsub=5.0000e-01    eta0=2.4800e-01    etab=-3.917e-03 \
nfactor=1.2140e+00 \
     em=4.1000e+07    pclm=1.8290e+00 \
  drout=5.0000e-01 \
     a0=5.8500e-01      a1=0.0000e+00      a2=1.0000e+00 \
   pvag=0.0000e+00    vsat=4.8240e+04     ags=2.4680e-01      b0=8.8320e-08      b1=0.0000e+00 \
  delta=1.0000e-02 pdiblcb=1.0000e+00 \
pdiblc1=1.0000e-04 pdiblc2=1.0000e-20 \
     w0=1.0000e-10 \
    dlc=5.6730e-08 \
    dwc=3.4490e-08     dwb=0.0000e+00     dwg=0.0000e+00 \
     ll=0.000e+00      lw=0.000e+00     lwl=0.000e+00 \
    lln=1.000e+00     lwn=1.000e+00      wl=0.0000e+00 \
     ww=1.8940e-16     wwl=-1.981e-21     wln=1.0000e+00 \
     wr=1.0000e+00     wwn=1.0400e+00 \
     at=3.3000e+04     ute=-1.300e+00 \
    kt1=-5.403e-01     kt2=2.2000e-02    kt1l=0.0000e+00 \
    ua1=0.0000e+00     ub1=0.0000e+00     uc1=0.0000e+00 \
    prt=0.0000e+00 \
   cgso=cgsdop        cgdo=cgsdop        cgbo=cgbop      \
   cgdl=2.5880e-10    cgsl=2.5880e-10  ckappa=6.0000e-01 \
     cf=0.0000e+00     elm=5.0000e+00 \
  xpart=1.0000e+00     clc=1.0000e-15     cle=6.0000e-01 \
\
   rdsw=0.0000e+00 \
   cdsc=2.5890e-03   cdscb=2.9430e-04   cdscd=4.3700e-04 \
   prwb=-9.731e-02    prwg=1.4770e-01     cit=0.0000e+00 \
tox=7.7540e-09+deltgox \
  ngate=0.0000e+00 \
    nlx=1.7700e-07 \
     xl=0.0000e+00+dell      xw=0.0000e+00+delw \
     af=1.4610e+00      kf=1.1910e-26      ef=1.0000e+00 \
   noia=5.2450e+17  noib=min(4.8160e+03,6.074e+04)   noic=8.0360e-13 \
     rd=0.0000e+00      rs=0.0000e+00     rsh=1.2900e+02+drdiffp \
   minr=1.000e-03 \
    rdc=0.0000e+00     rsc=0.0000e+00 lint=-1.164e-08 \
wint=3.4490e-08   ldif=0.000e+00    hdif=8.0000e-07 \
     xj=3.0000e-07      js=2.8000e-07 \
      n=1.0000e+00 \
  dskip=no          tlev=0           tlevc=0         \
    jsw=3.7000e-13 \
     cj=0.0000e+00    cjsw=0.0000e+00 \
     fc=0.0000e+00    fcsw=0.000e+00 \
     mj=5.6000e-01    mjsw=4.3000e-01 \
     pb=1.0200e+00    pbsw=1.0200e+00     xti=1.9700e+00
// Bulk Diode Model
model bulk_diode diode level=1 dskip=no \
     is=2.800e-07      isw=3.700e-13       n=1.0000000       ns=1.0000000   \
    cjo=1.526e-03       m=1.176e-01 \
    cjsw=0.000e+00       mjsw=4.300e-01 \
     fc=0.000e+00      tt=0.000e+00      vj=1.020e+00      vjsw=1.020e+00  \
     kf=0.000e+00      eg=1.11e+00     xti=1.973e+00      af=1.000e+00
ends modprf
// ----------------------------------------------------------------------
//-------------- END OF Section ------------------
endsection
endlibrary
//-------------- END OF LIBRARY ------------------
// Owner: amsAG
